************************************************************************
* auCdl Netlist:
*
* Library Name:  gsclib045
* Top Cell Name: AOI221X4
* View Name:     schematic
* Netlisted on:  Jun  4 07:38:50 2012
************************************************************************

*.BIPOLAR
*.RESI = 2000
*.EQUATION
*.SCALE METER
*.MEGA
.PARAM

*.GLOBAL VSS:G
+        VDD:P
+        ExtVDD:P
+        ExtVSS:G

*.PIN VSS
*+    VDD
*+    ExtVDD
*+    ExtVSS

************************************************************************
* Library Name: gsclib045
* Cell Name:    AOI221X4
* View Name:    schematic
************************************************************************

.SUBCKT AOI221X4 A0 A1 B0 B1 C0 VDD VSS Y
*.PININFO A0:I A1:I B0:I B1:I C0:I VDD:I VSS:I Y:O
Mmn2 net116 B0 VSS VSS g45n1svt m=1 l=45n w=1.04u
Mmn3 Y B1 net116 VSS g45n1svt m=1 l=45n w=1.04u
Mmn4 Y C0 VSS VSS g45n1svt m=1 l=45n w=1.04u
Mmn1 Y A1 net120 VSS g45n1svt m=1 l=45n w=1.04u
Mmn0 net120 A0 VSS VSS g45n1svt m=1 l=45n w=1.04u
Mmp3 net104 B1 net107 VDD g45p1svt m=1 l=45n w=1.56u
Mmp2 net104 B0 net107 VDD g45p1svt m=1 l=45n w=1.56u
Mmp0 net107 A0 VDD VDD g45p1svt m=1 l=45n w=1.56u
Mmp1 net107 A1 VDD VDD g45p1svt m=1 l=45n w=1.56u
Mmp4 Y C0 net104 VDD g45p1svt m=1 l=45n w=1.56u
.ENDS
