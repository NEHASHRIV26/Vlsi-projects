************************************************************************
* auCdl Netlist:
*
* Library Name:  gsclib045
* Top Cell Name: OAI22X4
* View Name:     schematic
* Netlisted on:  Jun  4 07:47:33 2012
************************************************************************

*.BIPOLAR
*.RESI = 2000
*.EQUATION
*.SCALE METER
*.MEGA
.PARAM

*.GLOBAL VDD:P
+        VSS:G
+        ExtVDD:P
+        ExtVSS:G

*.PIN VDD
*+    VSS
*+    ExtVDD
*+    ExtVSS

************************************************************************
* Library Name: gsclib045
* Cell Name:    OAI22X4
* View Name:    schematic
************************************************************************

.SUBCKT OAI22X4 A0 A1 B0 B1 VDD VSS Y
*.PININFO A0:I A1:I B0:I B1:I VDD:I VSS:I Y:O
Mmn0 net102 A0 VSS VSS g45n1svt m=1 l=45n w=1.04u
Mmn3 Y B1 net102 VSS g45n1svt m=1 l=45n w=1.04u
Mmn1 net102 A1 VSS VSS g45n1svt m=1 l=45n w=1.04u
Mmn2 Y B0 net102 VSS g45n1svt m=1 l=45n w=1.04u
Mmp3 Y B1 net85 VDD g45p1svt m=1 l=45n w=1.56u
Mmp1 Y A1 net93 VDD g45p1svt m=1 l=45n w=1.56u
Mmp0 net93 A0 VDD VDD g45p1svt m=1 l=45n w=1.56u
Mmp2 net85 B0 VDD VDD g45p1svt m=1 l=45n w=1.56u
.ENDS
