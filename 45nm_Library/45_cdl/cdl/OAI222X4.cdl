************************************************************************
* auCdl Netlist:
*
* Library Name:  gsclib045
* Top Cell Name: OAI222X4
* View Name:     schematic
* Netlisted on:  Jun  4 07:47:27 2012
************************************************************************

*.BIPOLAR
*.RESI = 2000
*.EQUATION
*.SCALE METER
*.MEGA
.PARAM

*.GLOBAL VDD:P
+        VSS:G
+        ExtVDD:P
+        ExtVSS:G

*.PIN VDD
*+    VSS
*+    ExtVDD
*+    ExtVSS

************************************************************************
* Library Name: gsclib045
* Cell Name:    OAI222X4
* View Name:    schematic
************************************************************************

.SUBCKT OAI222X4 A0 A1 B0 B1 C0 C1 VDD VSS Y
*.PININFO A0:I A1:I B0:I B1:I C0:I C1:I VDD:I VSS:I Y:O
Mmn5 Y C1 n0 VSS g45n1svt m=1 l=45n w=1.04u
Mmn4 Y C0 n0 VSS g45n1svt m=1 l=45n w=1.04u
Mmn3 n0 B1 n1 VSS g45n1svt m=1 l=45n w=1.04u
Mmn2 n0 B0 n1 VSS g45n1svt m=1 l=45n w=1.04u
Mmn0 n1 A0 VSS VSS g45n1svt m=1 l=45n w=1.04u
Mmn1 n1 A1 VSS VSS g45n1svt m=1 l=45n w=1.04u
Mmp5 Y C1 n4 VDD g45p1svt m=1 l=45n w=1.56u
Mmp4 n4 C0 VDD VDD g45p1svt m=1 l=45n w=1.56u
Mmp3 Y B1 n3 VDD g45p1svt m=1 l=45n w=1.56u
Mmp2 n3 B0 VDD VDD g45p1svt m=1 l=45n w=1.56u
Mmp1 Y A1 n2 VDD g45p1svt m=1 l=45n w=1.56u
Mmp0 n2 A0 VDD VDD g45p1svt m=1 l=45n w=1.56u
.ENDS
