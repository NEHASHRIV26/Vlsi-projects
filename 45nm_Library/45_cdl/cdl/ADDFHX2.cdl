************************************************************************
* auCdl Netlist:
*
* Library Name:  gsclib045
* Top Cell Name: ADDFHX2
* View Name:     schematic
* Netlisted on:  Jun  4 07:37:30 2012
************************************************************************

*.BIPOLAR
*.RESI = 2000
*.EQUATION
*.SCALE METER
*.MEGA
.PARAM

*.GLOBAL VDD:P
+        VSS:G
+        ExtVDD:P
+        ExtVSS:G

*.PIN VDD
*+    VSS
*+    ExtVDD
*+    ExtVSS

************************************************************************
* Library Name: gsclib045
* Cell Name:    ADDFHX2
* View Name:    schematic
************************************************************************

.SUBCKT ADDFHX2 A B CI CO S VDD VSS
*.PININFO A:I B:I CI:I VDD:I VSS:I CO:O S:O
Mmn5 n4 A VSS VSS g45n1svt m=1 l=45n w=205n
Mmn6 n4 B VSS VSS g45n1svt m=1 l=45n w=205n
Mmn4 COb CI n2 VSS g45n1svt m=1 l=45n w=205n
Mmn3 n2 B VSS VSS g45n1svt m=1 l=45n w=205n
Mmn2 n2 A VSS VSS g45n1svt m=1 l=45n w=205n
Mmn7 n4 CI VSS VSS g45n1svt m=1 l=45n w=205n
Mmn8 Sb COb n4 VSS g45n1svt m=1 l=45n w=205n
Mmn0 n0 A VSS VSS g45n1svt m=1 l=45n w=205n
Mmn1 COb B n0 VSS g45n1svt m=1 l=45n w=205n
Mmn12 CO COb VSS VSS g45n1svt m=1 l=45n w=520n
Mmn13 S Sb VSS VSS g45n1svt m=1 l=45n w=520n
Mmn11 Sb CI n7 VSS g45n1svt m=1 l=45n w=205n
Mmn10 n7 B n6 VSS g45n1svt m=1 l=45n w=205n
Mmn9 n6 A VSS VSS g45n1svt m=1 l=45n w=205n
Mmp2 n3 A VDD VDD g45p1svt m=1 l=45n w=310n
Mmp3 n3 B VDD VDD g45p1svt m=1 l=45n w=310n
Mmp4 COb CI n3 VDD g45p1svt m=1 l=45n w=310n
Mmp5 n5 A VDD VDD g45p1svt m=1 l=45n w=310n
Mmp6 n5 B VDD VDD g45p1svt m=1 l=45n w=310n
Mmp7 n5 CI VDD VDD g45p1svt m=1 l=45n w=310n
Mmp8 Sb COb n5 VDD g45p1svt m=1 l=45n w=310n
Mmp0 n1 A VDD VDD g45p1svt m=1 l=45n w=310n
Mmp1 COb B n1 VDD g45p1svt m=1 l=45n w=310n
Mmp12 CO COb VDD VDD g45p1svt m=1 l=45n w=780n
Mmp13 S Sb VDD VDD g45p1svt m=1 l=45n w=780n
Mmp11 Sb CI n9 VDD g45p1svt m=1 l=45n w=310n
Mmp10 n9 B n8 VDD g45p1svt m=1 l=45n w=310n
Mmp9 n8 A VDD VDD g45p1svt m=1 l=45n w=310n
.ENDS
