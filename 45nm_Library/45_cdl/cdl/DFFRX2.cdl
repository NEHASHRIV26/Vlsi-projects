************************************************************************
* auCdl Netlist:
*
* Library Name:  gsclib045
* Top Cell Name: DFFRX2
* View Name:     schematic
* Netlisted on:  Jun  4 07:41:20 2012
************************************************************************

*.BIPOLAR
*.RESI = 2000
*.EQUATION
*.SCALE METER
*.MEGA
.PARAM

*.GLOBAL VSS:G
+        VDD:P
+        ExtVDD:P
+        ExtVSS:G

*.PIN VSS
*+    VDD
*+    ExtVDD
*+    ExtVSS

************************************************************************
* Library Name: gsclib045
* Cell Name:    DFFRX2
* View Name:    schematic
************************************************************************

.SUBCKT DFFRX2 CK D Q QN RN VDD VSS
*.PININFO CK:I D:I RN:I VDD:I VSS:I Q:O QN:O
Mmn36 n25 mout n27 VSS g45n1svt m=1 l=45n w=145n
Mmn35 n27 RN VSS VSS g45n1svt m=1 l=45n w=145n
Mmn37 n20 CKbb n25 VSS g45n1svt m=1 l=45n w=145n
Mmn26 n20 CKb n21 VSS g45n1svt m=1 l=45n w=145n
Mmn25 n21 D VSS VSS g45n1svt m=1 l=45n w=145n
Mmn57 QN qint VSS VSS g45n1svt m=1 l=45n w=520n
Mmn55 Q qbint VSS VSS g45n1svt m=1 l=45n w=520n
Mmn45 n35 RN VSS VSS g45n1svt m=1 l=45n w=205n
Mmn46 qbint n30 n35 VSS g45n1svt m=1 l=45n w=205n
Mmn51 n30 CKb n40 VSS g45n1svt m=1 l=45n w=145n
Mmn50 n40 qbint VSS VSS g45n1svt m=1 l=45n w=145n
Mmn21 CKbb CKb VSS VSS g45n1svt m=1 l=45n w=145n
Mmn40 n30 CKbb mout VSS g45n1svt m=1 l=45n w=145n
Mmn30 mout n20 VSS VSS g45n1svt m=1 l=45n w=145n
Mmn56 qint qbint VSS VSS g45n1svt m=1 l=45n w=145n
Mmn20 CKb CK VSS VSS g45n1svt m=1 l=45n w=145n
Mmp26 n20 CKbb n22 VDD g45p1svt m=1 l=45n w=215n
Mmp25 n22 D VDD VDD g45p1svt m=1 l=45n w=215n
Mmp51 n30 CKbb n41 VDD g45p1svt m=1 l=45n w=215n
Mmp50 n41 qbint VDD VDD g45p1svt m=1 l=45n w=215n
Mmp57 QN qint VDD VDD g45p1svt m=1 l=45n w=780n
Mmp55 Q qbint VDD VDD g45p1svt m=1 l=45n w=780n
Mmp20 CKb CK VDD VDD g45p1svt m=1 l=45n w=215n
Mmp21 CKbb CKb VDD VDD g45p1svt m=1 l=45n w=215n
Mmp36 n26 mout VDD VDD g45p1svt m=1 l=45n w=215n
Mmp30 mout n20 VDD VDD g45p1svt m=1 l=45n w=215n
Mmp35 n26 RN VDD VDD g45p1svt m=1 l=45n w=215n
Mmp37 n20 CKb n26 VDD g45p1svt m=1 l=45n w=215n
Mmp46 qbint n30 VDD VDD g45p1svt m=1 l=45n w=310n
Mmp40 n30 CKb mout VDD g45p1svt m=1 l=45n w=215n
Mmp45 qbint RN VDD VDD g45p1svt m=1 l=45n w=310n
Mmp56 qint qbint VDD VDD g45p1svt m=1 l=45n w=215n
.ENDS
