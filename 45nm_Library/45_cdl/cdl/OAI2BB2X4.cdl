************************************************************************
* auCdl Netlist:
*
* Library Name:  gsclib045
* Top Cell Name: OAI2BB2X4
* View Name:     schematic
* Netlisted on:  Jun  4 07:47:46 2012
************************************************************************

*.BIPOLAR
*.RESI = 2000
*.EQUATION
*.SCALE METER
*.MEGA
.PARAM

*.GLOBAL VDD:P
+        VSS:G
+        ExtVDD:P
+        ExtVSS:G

*.PIN VDD
*+    VSS
*+    ExtVDD
*+    ExtVSS

************************************************************************
* Library Name: gsclib045
* Cell Name:    OAI2BB2X4
* View Name:    schematic
************************************************************************

.SUBCKT OAI2BB2X4 A0N A1N B0 B1 VDD VSS Y
*.PININFO A0N:I A1N:I B0:I B1:I VDD:I VSS:I Y:O
Mmn5 Y B1 n4 VSS g45n1svt m=1 l=45n w=1.04u
Mmn4 Y B0 n4 VSS g45n1svt m=1 l=45n w=1.04u
Mmn2 n4 n0 VSS VSS g45n1svt m=1 l=45n w=1.04u
Mmn0 n0 A0N VSS VSS g45n1svt m=1 l=45n w=260n
Mmn1 n1 A1N VSS VSS g45n1svt m=1 l=45n w=260n
Mmn3 n4 n1 VSS VSS g45n1svt m=1 l=45n w=1.04u
Mmp5 Y B1 n3 VDD g45p1svt m=1 l=45n w=1.56u
Mmp4 n3 B0 VDD VDD g45p1svt m=1 l=45n w=1.56u
Mmp0 n0 A0N VDD VDD g45p1svt m=1 l=45n w=390n
Mmp2 n2 n0 VDD VDD g45p1svt m=1 l=45n w=1.56u
Mmp1 n1 A1N VDD VDD g45p1svt m=1 l=45n w=390n
Mmp3 Y n1 n2 VDD g45p1svt m=1 l=45n w=1.56u
.ENDS
