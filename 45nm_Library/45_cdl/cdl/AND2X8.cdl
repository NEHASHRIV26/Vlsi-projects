************************************************************************
* auCdl Netlist:
*
* Library Name:  gsclib045
* Top Cell Name: AND2X8
* View Name:     schematic
* Netlisted on:  Jun  4 07:37:58 2012
************************************************************************

*.BIPOLAR
*.RESI = 2000
*.EQUATION
*.SCALE METER
*.MEGA
.PARAM

*.GLOBAL VSS:G
+        VDD:P
+        ExtVDD:P
+        ExtVSS:G

*.PIN VSS
*+    VDD
*+    ExtVDD
*+    ExtVSS

************************************************************************
* Library Name: gsclib045
* Cell Name:    AND2X8
* View Name:    schematic
************************************************************************

.SUBCKT AND2X8 A B VDD VSS Y
*.PININFO A:I B:I VDD:I VSS:I Y:O
Mmn2 Y n0 VSS VSS g45n1svt m=1 l=45n w=2.065u
Mmn0 net69 A VSS VSS g45n1svt m=1 l=45n w=520n
Mmn1 n0 B net69 VSS g45n1svt m=1 l=45n w=520n
Mmp1 n0 B VDD VDD g45p1svt m=1 l=45n w=780n
Mmp0 n0 A VDD VDD g45p1svt m=1 l=45n w=780n
Mmp2 Y n0 VDD VDD g45p1svt m=1 l=45n w=3.115u
.ENDS
