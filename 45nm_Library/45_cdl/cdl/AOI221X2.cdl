************************************************************************
* auCdl Netlist:
*
* Library Name:  gsclib045
* Top Cell Name: AOI221X2
* View Name:     schematic
* Netlisted on:  Jun  4 07:38:48 2012
************************************************************************

*.BIPOLAR
*.RESI = 2000
*.EQUATION
*.SCALE METER
*.MEGA
.PARAM

*.GLOBAL VSS:G
+        VDD:P
+        ExtVDD:P
+        ExtVSS:G

*.PIN VSS
*+    VDD
*+    ExtVDD
*+    ExtVSS

************************************************************************
* Library Name: gsclib045
* Cell Name:    AOI221X2
* View Name:    schematic
************************************************************************

.SUBCKT AOI221X2 A0 A1 B0 B1 C0 VDD VSS Y
*.PININFO A0:I A1:I B0:I B1:I C0:I VDD:I VSS:I Y:O
Mmn2 Y B0 net116 VSS g45n1svt m=1 l=45n w=520n
Mmn3 net116 B1 VSS VSS g45n1svt m=1 l=45n w=520n
Mmn4 Y C0 VSS VSS g45n1svt m=1 l=45n w=520n
Mmn1 Y A1 net124 VSS g45n1svt m=1 l=45n w=520n
Mmn0 net124 A0 VSS VSS g45n1svt m=1 l=45n w=520n
Mmp3 net104 B1 net103 VDD g45p1svt m=1 l=45n w=780n
Mmp2 net104 B0 net103 VDD g45p1svt m=1 l=45n w=780n
Mmp0 net103 A0 VDD VDD g45p1svt m=1 l=45n w=780n
Mmp1 net103 A1 VDD VDD g45p1svt m=1 l=45n w=780n
Mmp4 Y C0 net104 VDD g45p1svt m=1 l=45n w=780n
.ENDS
