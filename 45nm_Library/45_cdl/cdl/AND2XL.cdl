************************************************************************
* auCdl Netlist:
*
* Library Name:  gsclib045
* Top Cell Name: AND2XL
* View Name:     schematic
* Netlisted on:  Jun  4 07:38:00 2012
************************************************************************

*.BIPOLAR
*.RESI = 2000
*.EQUATION
*.SCALE METER
*.MEGA
.PARAM

*.GLOBAL VDD:P
+        VSS:G
+        ExtVDD:P
+        ExtVSS:G

*.PIN VDD
*+    VSS
*+    ExtVDD
*+    ExtVSS

************************************************************************
* Library Name: gsclib045
* Cell Name:    AND2XL
* View Name:    schematic
************************************************************************

.SUBCKT AND2XL A B VDD VSS Y
*.PININFO A:I B:I VDD:I VSS:I Y:O
Mmn2 Y net57 VSS VSS g45n1svt m=1 l=45n w=145n
Mmn0 net73 A VSS VSS g45n1svt m=1 l=45n w=145n
Mmn1 net57 B net73 VSS g45n1svt m=1 l=45n w=145n
Mmp1 net57 B VDD VDD g45p1svt m=1 l=45n w=215n
Mmp0 net57 A VDD VDD g45p1svt m=1 l=45n w=215n
Mmp2 Y net57 VDD VDD g45p1svt m=1 l=45n w=215n
.ENDS
