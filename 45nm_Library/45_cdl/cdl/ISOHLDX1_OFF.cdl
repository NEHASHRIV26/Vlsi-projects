************************************************************************
* auCdl Netlist:
*
* Library Name:  gsclib045
* Top Cell Name: ISOHLDX1_OFF
* View Name:     schematic
* Netlisted on:  Jun  4 07:43:19 2012
************************************************************************

*.BIPOLAR
*.RESI = 2000
*.EQUATION
*.SCALE METER
*.MEGA
.PARAM

*.GLOBAL VSS:G
+        VDD:P
+        ExtVDD:P
+        ExtVSS:G

*.PIN VSS
*+    VDD
*+    ExtVDD
*+    ExtVSS

************************************************************************
* Library Name: gsclib045
* Cell Name:    ISOHLDX1_OFF
* View Name:    schematic
************************************************************************

.SUBCKT ISOHLDX1_OFF D ExtVDD ISO Q VDD VSS
*.PININFO D:I ExtVDD:I ISO:I VDD:I VSS:I Q:O
Mmn5 net257 D VSS VSS g45n1svt m=1 l=45n w=145n
Mmn6 n0 GNb net257 VSS g45n1svt m=1 l=45n w=145n
Mmn16 n0 GNbb net245 VSS g45n1svt m=1 l=45n w=145n
Mmn15 net245 Qint VSS VSS g45n1svt m=1 l=45n w=145n
Mmn21 Q Qbint VSS VSS g45n1svt m=1 l=45n w=260n
Mmn0 GNb ISO VSS VSS g45n1svt m=1 l=45n w=145n
Mmn1 GNbb GNb VSS VSS g45n1svt m=1 l=45n w=145n
Mmn10 Qint n0 VSS VSS g45n1svt m=1 l=45n w=145n
Mmn20 Qbint Qint VSS VSS g45n1svt m=1 l=45n w=260n
Mmp6 n0 GNbb net220 ExtVDD g45p1svt m=1 l=45n w=215n
Mmp5 net220 D ExtVDD ExtVDD g45p1svt m=1 l=45n w=215n
Mmp16 n0 GNb net212 ExtVDD g45p1svt m=1 l=45n w=215n
Mmp15 net212 Qint ExtVDD ExtVDD g45p1svt m=1 l=45n w=215n
Mmp21 Q Qbint ExtVDD ExtVDD g45p1svt m=1 l=45n w=390n
Mmp0 GNb ISO ExtVDD ExtVDD g45p1svt m=1 l=45n w=215n
Mmp1 GNbb GNb ExtVDD ExtVDD g45p1svt m=1 l=45n w=215n
Mmp10 Qint n0 ExtVDD ExtVDD g45p1svt m=1 l=45n w=215n
Mmp20 Qbint Qint ExtVDD ExtVDD g45p1svt m=1 l=45n w=390n
.ENDS
