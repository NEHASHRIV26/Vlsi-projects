************************************************************************
* auCdl Netlist:
*
* Library Name:  gsclib045
* Top Cell Name: NAND3BX4
* View Name:     schematic
* Netlisted on:  Jun  4 07:45:19 2012
************************************************************************

*.BIPOLAR
*.RESI = 2000
*.EQUATION
*.SCALE METER
*.MEGA
.PARAM

*.GLOBAL VSS:G
+        VDD:P
+        ExtVDD:P
+        ExtVSS:G

*.PIN VSS
*+    VDD
*+    ExtVDD
*+    ExtVSS

************************************************************************
* Library Name: gsclib045
* Cell Name:    NAND3BX4
* View Name:    schematic
************************************************************************

.SUBCKT NAND3BX4 AN B C VDD VSS Y
*.PININFO AN:I B:I C:I VDD:I VSS:I Y:O
Mmn3 Y C n1 VSS g45n1svt m=1 l=45n w=1.04u
Mmn0 n0 AN VSS VSS g45n1svt m=1 l=45n w=260n
Mmn2 n1 B n2 VSS g45n1svt m=1 l=45n w=1.04u
Mmn1 n2 n0 VSS VSS g45n1svt m=1 l=45n w=1.04u
Mmp1 Y n0 VDD VDD g45p1svt m=1 l=45n w=1.56u
Mmp3 Y C VDD VDD g45p1svt m=1 l=45n w=1.56u
Mmp0 n0 AN VDD VDD g45p1svt m=1 l=45n w=390n
Mmp2 Y B VDD VDD g45p1svt m=1 l=45n w=1.56u
.ENDS
