************************************************************************
* auCdl Netlist:
*
* Library Name:  gsclib045
* Top Cell Name: FILL1
* View Name:     schematic
* Netlisted on:  Jun  4 07:42:39 2012
************************************************************************

*.BIPOLAR
*.RESI = 2000
*.EQUATION
*.SCALE METER
*.MEGA
.PARAM

*.GLOBAL VSS:G
+        VDD:P
+        ExtVDD:P
+        ExtVSS:G

*.PIN VSS
*+    VDD
*+    ExtVDD
*+    ExtVSS

************************************************************************
* Library Name: gsclib045
* Cell Name:    FILL1
* View Name:    schematic
************************************************************************

.SUBCKT FILL1 VDD VSS
*.PININFO VDD:I VSS:I
.ENDS
