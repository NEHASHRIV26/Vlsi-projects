************************************************************************
* auCdl Netlist:
*
* Library Name:  gsclib045
* Top Cell Name: OR2X6
* View Name:     schematic
* Netlisted on:  Jun  4 07:48:14 2012
************************************************************************

*.BIPOLAR
*.RESI = 2000
*.EQUATION
*.SCALE METER
*.MEGA
.PARAM

*.GLOBAL VDD:P
+        VSS:G
+        ExtVDD:P
+        ExtVSS:G

*.PIN VDD
*+    VSS
*+    ExtVDD
*+    ExtVSS

************************************************************************
* Library Name: gsclib045
* Cell Name:    OR2X6
* View Name:    schematic
************************************************************************

.SUBCKT OR2X6 A B VDD VSS Y
*.PININFO A:I B:I VDD:I VSS:I Y:O
Mmn2 Y n0 VSS VSS g45n1svt m=1 l=45n w=1.55u
Mmn0 n0 A VSS VSS g45n1svt m=1 l=45n w=520n
Mmn1 n0 B VSS VSS g45n1svt m=1 l=45n w=520n
Mmp1 n0 B n1 VDD g45p1svt m=1 l=45n w=780n
Mmp2 Y n0 VDD VDD g45p1svt m=1 l=45n w=2.35u
Mmp0 n1 A VDD VDD g45p1svt m=1 l=45n w=780n
.ENDS
