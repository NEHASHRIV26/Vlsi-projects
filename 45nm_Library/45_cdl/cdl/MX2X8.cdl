************************************************************************
* auCdl Netlist:
*
* Library Name:  gsclib045
* Top Cell Name: MX2X8
* View Name:     schematic
* Netlisted on:  Jun  4 07:44:19 2012
************************************************************************

*.BIPOLAR
*.RESI = 2000
*.EQUATION
*.SCALE METER
*.MEGA
.PARAM

*.GLOBAL VSS:G
+        VDD:P
+        ExtVDD:P
+        ExtVSS:G

*.PIN VSS
*+    VDD
*+    ExtVDD
*+    ExtVSS

************************************************************************
* Library Name: gsclib045
* Cell Name:    MX2X8
* View Name:    schematic
************************************************************************

.SUBCKT MX2X8 A B S0 VDD VSS Y
*.PININFO A:I B:I S0:I VDD:I VSS:I Y:O
Mmn3 n5 B VSS VSS g45n1svt m=1 l=45n w=205n
Mmn4 n0 S0 n5 VSS g45n1svt m=1 l=45n w=205n
Mmn0 S0b S0 VSS VSS g45n1svt m=1 l=45n w=145n
Mmn1 n3 A VSS VSS g45n1svt m=1 l=45n w=205n
Mmn5 Y n0 VSS VSS g45n1svt m=1 l=45n w=2.065u
Mmn2 n0 S0b n3 VSS g45n1svt m=1 l=45n w=205n
Mmp4 n0 S0b n6 VDD g45p1svt m=1 l=45n w=310n
Mmp3 n6 B VDD VDD g45p1svt m=1 l=45n w=310n
Mmp5 Y n0 VDD VDD g45p1svt m=1 l=45n w=3.115u
Mmp0 S0b S0 VDD VDD g45p1svt m=1 l=45n w=215n
Mmp2 n0 S0 n4 VDD g45p1svt m=1 l=45n w=310n
Mmp1 n4 A VDD VDD g45p1svt m=1 l=45n w=310n
.ENDS
