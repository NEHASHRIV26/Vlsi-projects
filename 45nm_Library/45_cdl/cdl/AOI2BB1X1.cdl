************************************************************************
* auCdl Netlist:
*
* Library Name:  gsclib045
* Top Cell Name: AOI2BB1X1
* View Name:     schematic
* Netlisted on:  Jun  4 07:39:08 2012
************************************************************************

*.BIPOLAR
*.RESI = 2000
*.EQUATION
*.SCALE METER
*.MEGA
.PARAM

*.GLOBAL VSS:G
+        VDD:P
+        ExtVDD:P
+        ExtVSS:G

*.PIN VSS
*+    VDD
*+    ExtVDD
*+    ExtVSS

************************************************************************
* Library Name: gsclib045
* Cell Name:    AOI2BB1X1
* View Name:    schematic
************************************************************************

.SUBCKT AOI2BB1X1 A0N A1N B0 VDD VSS Y
*.PININFO A0N:I A1N:I B0:I VDD:I VSS:I Y:O
Mmn2 Y B0 VSS VSS g45n1svt m=1 l=45n w=260n
Mmn1 n0 A1N VSS VSS g45n1svt m=1 l=45n w=145n
Mmn3 Y n0 VSS VSS g45n1svt m=1 l=45n w=260n
Mmn0 n0 A0N VSS VSS g45n1svt m=1 l=45n w=145n
Mmp3 Y n0 n2 VDD g45p1svt m=1 l=45n w=390n
Mmp2 n2 B0 VDD VDD g45p1svt m=1 l=45n w=390n
Mmp1 n0 A1N n1 VDD g45p1svt m=1 l=45n w=215n
Mmp0 n1 A0N VDD VDD g45p1svt m=1 l=45n w=215n
.ENDS
