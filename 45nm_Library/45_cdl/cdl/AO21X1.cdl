************************************************************************
* auCdl Netlist:
*
* Library Name:  gsclib045
* Top Cell Name: AO21X1
* View Name:     schematic
* Netlisted on:  Jun  4 07:38:20 2012
************************************************************************

*.BIPOLAR
*.RESI = 2000
*.EQUATION
*.SCALE METER
*.MEGA
.PARAM

*.GLOBAL VDD:P
+        VSS:G
+        ExtVDD:P
+        ExtVSS:G

*.PIN VDD
*+    VSS
*+    ExtVDD
*+    ExtVSS

************************************************************************
* Library Name: gsclib045
* Cell Name:    AO21X1
* View Name:    schematic
************************************************************************

.SUBCKT AO21X1 A0 A1 B0 VDD VSS Y
*.PININFO A0:I A1:I B0:I VDD:I VSS:I Y:O
Mmn1 net049 A1 net104 VSS g45n1svt m=1 l=45n w=145n
Mmn0 net104 A0 VSS VSS g45n1svt m=1 l=45n w=145n
Mmn3 Y net049 VSS VSS g45n1svt m=1 l=45n w=260n
Mmn2 net049 B0 VSS VSS g45n1svt m=1 l=45n w=145n
Mmp1 net96 A1 VDD VDD g45p1svt m=1 l=45n w=215n
Mmp0 net96 A0 VDD VDD g45p1svt m=1 l=45n w=215n
Mmp3 Y net049 VDD VDD g45p1svt m=1 l=45n w=390n
Mmp2 net049 B0 net96 VDD g45p1svt m=1 l=45n w=215n
.ENDS
