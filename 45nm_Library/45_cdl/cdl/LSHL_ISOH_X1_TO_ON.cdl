************************************************************************
* auCdl Netlist:
*
* Library Name:  gsclib045
* Top Cell Name: LSHL_ISOH_X1_TO_ON
* View Name:     schematic
* Netlisted on:  Jun  4 07:43:38 2012
************************************************************************

*.BIPOLAR
*.RESI = 2000
*.EQUATION
*.SCALE METER
*.MEGA
.PARAM

*.GLOBAL VDD:P
+        VSS:G
+        ExtVDD:P
+        ExtVSS:G

*.PIN VDD
*+    VSS
*+    ExtVDD
*+    ExtVSS

************************************************************************
* Library Name: gsclib045
* Cell Name:    LSHL_ISOH_X1_TO_ON
* View Name:    schematic
************************************************************************

.SUBCKT LSHL_ISOH_X1_TO_ON A ISO VDD VSS Y
*.PININFO A:I ISO:I VDD:I VSS:I Y:O
MNM1 VSS ISO ison VSS g45n1svt m=1 l=45n w=145n
MNM3 gatedVSS ison VSS VSS g45n1svt m=1 l=45n w=520n
MNM0 Y n0 gatedVSS VSS g45n1svt m=1 l=45n w=260n
Mmn0 gatedVSS A n0 VSS g45n1svt m=1 l=45n w=145n
MPM1 ison ISO VDD VDD g45p1svt m=1 l=45n w=215n
MPM4 Y ison VDD VDD g45p1svt m=1 l=45n w=390n
MPM0 Y n0 VDD VDD g45p1svt m=1 l=45n w=390n
Mmp0 n0 A VDD VDD g45p1svt m=1 l=45n w=215n
.ENDS
