************************************************************************
* auCdl Netlist:
*
* Library Name:  gsclib045
* Top Cell Name: AOI32X4
* View Name:     schematic
* Netlisted on:  Jun  4 07:39:33 2012
************************************************************************

*.BIPOLAR
*.RESI = 2000
*.EQUATION
*.SCALE METER
*.MEGA
.PARAM

*.GLOBAL VDD:P
+        VSS:G
+        ExtVDD:P
+        ExtVSS:G

*.PIN VDD
*+    VSS
*+    ExtVDD
*+    ExtVSS

************************************************************************
* Library Name: gsclib045
* Cell Name:    AOI32X4
* View Name:    schematic
************************************************************************

.SUBCKT AOI32X4 A0 A1 A2 B0 B1 VDD VSS Y
*.PININFO A0:I A1:I A2:I B0:I B1:I VDD:I VSS:I Y:O
Mmn3 net118 B0 VSS VSS g45n1svt m=1 l=45n w=1.04u
Mmn2 Y A2 net126 VSS g45n1svt m=1 l=45n w=1.04u
Mmn0 net122 A0 VSS VSS g45n1svt m=1 l=45n w=1.04u
Mmn1 net126 A1 net122 VSS g45n1svt m=1 l=45n w=1.04u
Mmn4 Y B1 net118 VSS g45n1svt m=1 l=45n w=1.04u
Mmp3 Y B0 net106 VDD g45p1svt m=1 l=45n w=1.56u
Mmp4 Y B1 net106 VDD g45p1svt m=1 l=45n w=1.56u
Mmp2 net106 A2 VDD VDD g45p1svt m=1 l=45n w=1.56u
Mmp1 net106 A1 VDD VDD g45p1svt m=1 l=45n w=1.56u
Mmp0 net106 A0 VDD VDD g45p1svt m=1 l=45n w=1.56u
.ENDS
