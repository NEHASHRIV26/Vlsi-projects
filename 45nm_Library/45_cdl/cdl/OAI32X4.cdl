************************************************************************
* auCdl Netlist:
*
* Library Name:  gsclib045
* Top Cell Name: OAI32X4
* View Name:     schematic
* Netlisted on:  Jun  4 07:47:59 2012
************************************************************************

*.BIPOLAR
*.RESI = 2000
*.EQUATION
*.SCALE METER
*.MEGA
.PARAM

*.GLOBAL VDD:P
+        VSS:G
+        ExtVDD:P
+        ExtVSS:G

*.PIN VDD
*+    VSS
*+    ExtVDD
*+    ExtVSS

************************************************************************
* Library Name: gsclib045
* Cell Name:    OAI32X4
* View Name:    schematic
************************************************************************

.SUBCKT OAI32X4 A0 A1 A2 B0 B1 VDD VSS Y
*.PININFO A0:I A1:I A2:I B0:I B1:I VDD:I VSS:I Y:O
Mmn3 Y B0 n0 VSS g45n1svt m=1 l=45n w=1.04u
Mmn4 Y B1 n0 VSS g45n1svt m=1 l=45n w=1.04u
Mmn2 n0 A2 VSS VSS g45n1svt m=1 l=45n w=1.04u
Mmn0 n0 A0 VSS VSS g45n1svt m=1 l=45n w=1.04u
Mmn1 n0 A1 VSS VSS g45n1svt m=1 l=45n w=1.04u
Mmp2 Y A2 n2 VDD g45p1svt m=1 l=45n w=1.56u
Mmp3 n4 B0 VDD VDD g45p1svt m=1 l=45n w=1.56u
Mmp0 n1 A0 VDD VDD g45p1svt m=1 l=45n w=1.56u
Mmp4 Y B1 n4 VDD g45p1svt m=1 l=45n w=1.56u
Mmp1 n2 A1 n1 VDD g45p1svt m=1 l=45n w=1.56u
.ENDS
