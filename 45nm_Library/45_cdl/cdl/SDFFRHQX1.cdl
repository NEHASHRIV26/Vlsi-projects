************************************************************************
* auCdl Netlist:
*
* Library Name:  gsclib045
* Top Cell Name: SDFFRHQX1
* View Name:     schematic
* Netlisted on:  Jun  4 07:49:34 2012
************************************************************************

*.BIPOLAR
*.RESI = 2000
*.EQUATION
*.SCALE METER
*.MEGA
.PARAM

*.GLOBAL VSS:G
+        VDD:P
+        ExtVDD:P
+        ExtVSS:G

*.PIN VSS
*+    VDD
*+    ExtVDD
*+    ExtVSS

************************************************************************
* Library Name: gsclib045
* Cell Name:    SDFFRHQX1
* View Name:    schematic
************************************************************************

.SUBCKT SDFFRHQX1 CK D Q RN SE SI VDD VSS
*.PININFO CK:I D:I RN:I SE:I SI:I VDD:I VSS:I Q:O
Mmn36 net422 mout net426 VSS g45n1svt m=1 l=45n w=205n
Mmn35 net426 RN VSS VSS g45n1svt m=1 l=45n w=205n
Mmn37 n20 CKbb net422 VSS g45n1svt m=1 l=45n w=205n
Mmn13 net442 SI VSS VSS g45n1svt m=1 l=45n w=260n
Mmn14 Db SE net442 VSS g45n1svt m=1 l=45n w=260n
Mmn12 Db SEb net450 VSS g45n1svt m=1 l=45n w=260n
Mmn11 net450 D VSS VSS g45n1svt m=1 l=45n w=260n
Mmn55 Q qbint VSS VSS g45n1svt m=1 l=45n w=260n
Mmn45 net337 RN VSS VSS g45n1svt m=1 l=45n w=205n
Mmn46 qbint n30 net337 VSS g45n1svt m=1 l=45n w=205n
Mmn51 n30 CKb net405 VSS g45n1svt m=1 l=45n w=205n
Mmn50 net405 qbint VSS VSS g45n1svt m=1 l=45n w=205n
Mmn20 CKb CK VSS VSS g45n1svt m=1 l=45n w=145n
Mmn40 n30 CKbb mout VSS g45n1svt m=1 l=45n w=205n
Mmn30 mout n20 VSS VSS g45n1svt m=1 l=45n w=205n
Mmn21 CKbb CKb VSS VSS g45n1svt m=1 l=45n w=145n
Mmn10 SEb SE VSS VSS g45n1svt m=1 l=45n w=145n
Mmn25 n20 CKb Db VSS g45n1svt m=1 l=45n w=205n
Mmp14 Db SEb net373 VDD g45p1svt m=1 l=45n w=390n
Mmp13 net373 SI VDD VDD g45p1svt m=1 l=45n w=390n
Mmp12 Db SE net381 VDD g45p1svt m=1 l=45n w=390n
Mmp11 net381 D VDD VDD g45p1svt m=1 l=45n w=390n
Mmp51 n30 CKbb net326 VDD g45p1svt m=1 l=45n w=310n
Mmp50 net326 qbint VDD VDD g45p1svt m=1 l=45n w=310n
Mmp55 Q qbint VDD VDD g45p1svt m=1 l=45n w=390n
Mmp20 CKb CK VDD VDD g45p1svt m=1 l=45n w=215n
Mmp46 qbint n30 VDD VDD g45p1svt m=1 l=45n w=310n
Mmp45 VDD RN qbint VDD g45p1svt m=1 l=45n w=310n
Mmp35 net349 RN VDD VDD g45p1svt m=1 l=45n w=310n
Mmp36 net349 mout VDD VDD g45p1svt m=1 l=45n w=310n
Mmp37 n20 CKb net349 VDD g45p1svt m=1 l=45n w=310n
Mmp40 n30 CKb mout VDD g45p1svt m=1 l=45n w=310n
Mmp30 mout n20 VDD VDD g45p1svt m=1 l=45n w=310n
Mmp21 CKbb CKb VDD VDD g45p1svt m=1 l=45n w=215n
Mmp25 n20 CKbb Db VDD g45p1svt m=1 l=45n w=310n
Mmp10 SEb SE VDD VDD g45p1svt m=1 l=45n w=215n
.ENDS
