************************************************************************
* auCdl Netlist:
*
* Library Name:  gsclib045
* Top Cell Name: AOI21X1
* View Name:     schematic
* Netlisted on:  Jun  4 07:38:40 2012
************************************************************************

*.BIPOLAR
*.RESI = 2000
*.EQUATION
*.SCALE METER
*.MEGA
.PARAM

*.GLOBAL VSS:G
+        VDD:P
+        ExtVDD:P
+        ExtVSS:G

*.PIN VSS
*+    VDD
*+    ExtVDD
*+    ExtVSS

************************************************************************
* Library Name: gsclib045
* Cell Name:    AOI21X1
* View Name:    schematic
************************************************************************

.SUBCKT AOI21X1 A0 A1 B0 VDD VSS Y
*.PININFO A0:I A1:I B0:I VDD:I VSS:I Y:O
Mmn2 Y B0 VSS VSS g45n1svt m=1 l=45n w=260n
Mmn0 net78 A0 VSS VSS g45n1svt m=1 l=45n w=260n
Mmn1 Y A1 net78 VSS g45n1svt m=1 l=45n w=260n
Mmp2 Y B0 net62 VDD g45p1svt m=1 l=45n w=390n
Mmp1 net62 A1 VDD VDD g45p1svt m=1 l=45n w=390n
Mmp0 net62 A0 VDD VDD g45p1svt m=1 l=45n w=390n
.ENDS
