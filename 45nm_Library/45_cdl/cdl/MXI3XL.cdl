************************************************************************
* auCdl Netlist:
*
* Library Name:  gsclib045
* Top Cell Name: MXI3XL
* View Name:     schematic
* Netlisted on:  Jun  4 07:44:52 2012
************************************************************************

*.BIPOLAR
*.RESI = 2000
*.EQUATION
*.SCALE METER
*.MEGA
.PARAM

*.GLOBAL VSS:G
+        VDD:P
+        ExtVDD:P
+        ExtVSS:G

*.PIN VSS
*+    VDD
*+    ExtVDD
*+    ExtVSS

************************************************************************
* Library Name: gsclib045
* Cell Name:    MXI3XL
* View Name:    schematic
************************************************************************

.SUBCKT MXI3XL A B C S0 S1 VDD VSS Y
*.PININFO A:I B:I C:I S0:I S1:I VDD:I VSS:I Y:O
Mmn4 n4 B VSS VSS g45n1svt m=1 l=45n w=145n
Mmn5 n0 S0 n4 VSS g45n1svt m=1 l=45n w=145n
Mmn3 n0 S0b n2 VSS g45n1svt m=1 l=45n w=145n
Mmn2 n2 A VSS VSS g45n1svt m=1 l=45n w=145n
Mmn11 Y n1 VSS VSS g45n1svt m=1 l=45n w=145n
Mmn10 n1 S1 n8 VSS g45n1svt m=1 l=45n w=145n
Mmn9 n8 Cp VSS VSS g45n1svt m=1 l=45n w=145n
Mmn8 n1 S1b n6 VSS g45n1svt m=1 l=45n w=145n
Mmn7 n6 n0 VSS VSS g45n1svt m=1 l=45n w=145n
Mmn6 Cp C VSS VSS g45n1svt m=1 l=45n w=145n
Mmn0 S0b S0 VSS VSS g45n1svt m=1 l=45n w=145n
Mmn1 S1b S1 VSS VSS g45n1svt m=1 l=45n w=145n
Mmp5 n0 S0b n5 VDD g45p1svt m=1 l=45n w=215n
Mmp4 n5 B VDD VDD g45p1svt m=1 l=45n w=215n
Mmp3 n0 S0 n3 VDD g45p1svt m=1 l=45n w=215n
Mmp2 n3 A VDD VDD g45p1svt m=1 l=45n w=215n
Mmp8 n1 S1 n7 VDD g45p1svt m=1 l=45n w=215n
Mmp7 n7 n0 VDD VDD g45p1svt m=1 l=45n w=215n
Mmp11 Y n1 VDD VDD g45p1svt m=1 l=45n w=215n
Mmp9 n9 Cp VDD VDD g45p1svt m=1 l=45n w=215n
Mmp10 n1 S1b n9 VDD g45p1svt m=1 l=45n w=215n
Mmp6 Cp C VDD VDD g45p1svt m=1 l=45n w=215n
Mmp1 S1b S1 VDD VDD g45p1svt m=1 l=45n w=215n
Mmp0 S0b S0 VDD VDD g45p1svt m=1 l=45n w=215n
.ENDS
