************************************************************************
* auCdl Netlist:
*
* Library Name:  gsclib045
* Top Cell Name: NAND2X2
* View Name:     schematic
* Netlisted on:  Jun  4 07:45:08 2012
************************************************************************

*.BIPOLAR
*.RESI = 2000
*.EQUATION
*.SCALE METER
*.MEGA
.PARAM

*.GLOBAL VSS:G
+        VDD:P
+        ExtVDD:P
+        ExtVSS:G

*.PIN VSS
*+    VDD
*+    ExtVDD
*+    ExtVSS

************************************************************************
* Library Name: gsclib045
* Cell Name:    NAND2X2
* View Name:    schematic
************************************************************************

.SUBCKT NAND2X2 A B VDD VSS Y
*.PININFO A:I B:I VDD:I VSS:I Y:O
Mmn1 Y B n0 VSS g45n1svt m=1 l=45n w=520n
Mmn0 n0 A VSS VSS g45n1svt m=1 l=45n w=520n
Mmp1 Y B VDD VDD g45p1svt m=1 l=45n w=780n
Mmp0 Y A VDD VDD g45p1svt m=1 l=45n w=780n
.ENDS
