************************************************************************
* auCdl Netlist:
*
* Library Name:  gsclib045
* Top Cell Name: BUFX16
* View Name:     schematic
* Netlisted on:  Jun  4 07:39:48 2012
************************************************************************

*.BIPOLAR
*.RESI = 2000
*.EQUATION
*.SCALE METER
*.MEGA
.PARAM

*.GLOBAL VDD:P
+        VSS:G
+        ExtVDD:P
+        ExtVSS:G

*.PIN VDD
*+    VSS
*+    ExtVDD
*+    ExtVSS

************************************************************************
* Library Name: gsclib045
* Cell Name:    BUFX16
* View Name:    schematic
************************************************************************

.SUBCKT BUFX16 A VDD VSS Y
*.PININFO A:I VDD:I VSS:I Y:O
Mmn1 VSS n0 Y VSS g45n1svt m=1 l=45n w=4.13u
Mmn0 VSS A n0 VSS g45n1svt m=1 l=45n w=1.04u
Mmp1 Y n0 VDD VDD g45p1svt m=1 l=45n w=6.23u
Mmp0 n0 A VDD VDD g45p1svt m=1 l=45n w=1.56u
.ENDS
