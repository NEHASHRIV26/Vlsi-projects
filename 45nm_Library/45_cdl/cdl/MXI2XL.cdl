************************************************************************
* auCdl Netlist:
*
* Library Name:  gsclib045
* Top Cell Name: MXI2XL
* View Name:     schematic
* Netlisted on:  Jun  4 07:44:46 2012
************************************************************************

*.BIPOLAR
*.RESI = 2000
*.EQUATION
*.SCALE METER
*.MEGA
.PARAM

*.GLOBAL VDD:P
+        VSS:G
+        ExtVDD:P
+        ExtVSS:G

*.PIN VDD
*+    VSS
*+    ExtVDD
*+    ExtVSS

************************************************************************
* Library Name: gsclib045
* Cell Name:    MXI2XL
* View Name:    schematic
************************************************************************

.SUBCKT MXI2XL A B S0 VDD VSS Y
*.PININFO A:I B:I S0:I VDD:I VSS:I Y:O
Mmn3 n5 B VSS VSS g45n1svt m=1 l=45n w=145n
Mmn4 Y S0 n5 VSS g45n1svt m=1 l=45n w=145n
Mmn2 Y S0b n3 VSS g45n1svt m=1 l=45n w=145n
Mmn1 n3 A VSS VSS g45n1svt m=1 l=45n w=145n
Mmn0 S0b S0 VSS VSS g45n1svt m=1 l=45n w=145n
Mmp4 Y S0b n6 VDD g45p1svt m=1 l=45n w=215n
Mmp3 n6 B VDD VDD g45p1svt m=1 l=45n w=215n
Mmp2 Y S0 n4 VDD g45p1svt m=1 l=45n w=215n
Mmp1 n4 A VDD VDD g45p1svt m=1 l=45n w=215n
Mmp0 S0b S0 VDD VDD g45p1svt m=1 l=45n w=215n
.ENDS
