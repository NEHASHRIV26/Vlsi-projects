************************************************************************
* auCdl Netlist:
*
* Library Name:  gsclib045
* Top Cell Name: CLKBUFX6
* View Name:     schematic
* Netlisted on:  Jun  4 07:40:18 2012
************************************************************************

*.BIPOLAR
*.RESI = 2000
*.EQUATION
*.SCALE METER
*.MEGA
.PARAM

*.GLOBAL VSS:G
+        VDD:P
+        ExtVDD:P
+        ExtVSS:G

*.PIN VSS
*+    VDD
*+    ExtVDD
*+    ExtVSS

************************************************************************
* Library Name: gsclib045
* Cell Name:    CLKBUFX6
* View Name:    schematic
************************************************************************

.SUBCKT CLKBUFX6 A VDD VSS Y
*.PININFO A:I VDD:I VSS:I Y:O
Mmn1 Y net44 VSS VSS g45n1svt m=1 l=45n w=1.55u
Mmn0 net44 A VSS VSS g45n1svt m=1 l=45n w=520n
Mmp1 Y net44 VDD VDD g45p1svt m=1 l=45n w=2.35u
Mmp0 net44 A VDD VDD g45p1svt m=1 l=45n w=780n
.ENDS
