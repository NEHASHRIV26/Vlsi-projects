************************************************************************
* auCdl Netlist:
*
* Library Name:  gsclib045
* Top Cell Name: LSLHX1_FROM
* View Name:     schematic
* Netlisted on:  Jun  4 07:43:49 2012
************************************************************************

*.BIPOLAR
*.RESI = 2000
*.EQUATION
*.SCALE METER
*.MEGA
.PARAM

*.GLOBAL VSS:G
+        ExtVDD:P
+        VDD:P
+        ExtVSS:G

*.PIN VSS
*+    ExtVDD
*+    VDD
*+    ExtVSS

************************************************************************
* Library Name: gsclib045
* Cell Name:    LSLHX1_FROM
* View Name:    schematic
************************************************************************

.SUBCKT LSLHX1_FROM A ExtVDD VDD VSS Y
*.PININFO A:I ExtVDD:I VDD:I VSS:I Y:O
Mmn0 Y Ybint VSS VSS g45n1svt m=1 l=45n w=260n
MNM2 VSS A Ab VSS g45n1svt m=1 l=45n w=145n
MNM0 Ybint A VSS VSS g45n1svt m=1 l=45n w=780n
MNM1 Yint Ab VSS VSS g45n1svt m=1 l=45n w=780n
MPM0 Ybint Yint ExtVDD ExtVDD g45p1svt m=1 l=45n w=215n
MPM1 Yint Ybint ExtVDD ExtVDD g45p1svt m=1 l=45n w=215n
Mmp0 Y Ybint ExtVDD ExtVDD g45p1svt m=1 l=45n w=390n
MPM2 Ab A VDD VDD g45p1svt m=1 l=45n w=215n
.ENDS
