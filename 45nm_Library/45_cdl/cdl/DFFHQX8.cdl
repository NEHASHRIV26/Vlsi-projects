************************************************************************
* auCdl Netlist:
*
* Library Name:  gsclib045
* Top Cell Name: DFFHQX8
* View Name:     schematic
* Netlisted on:  Jun  4 07:40:58 2012
************************************************************************

*.BIPOLAR
*.RESI = 2000
*.EQUATION
*.SCALE METER
*.MEGA
.PARAM

*.GLOBAL VSS:G
+        VDD:P
+        ExtVDD:P
+        ExtVSS:G

*.PIN VSS
*+    VDD
*+    ExtVDD
*+    ExtVSS

************************************************************************
* Library Name: gsclib045
* Cell Name:    DFFHQX8
* View Name:    schematic
************************************************************************

.SUBCKT DFFHQX8 CK D Q VDD VSS
*.PININFO CK:I D:I VDD:I VSS:I Q:O
Mmn26 n20 CKb n21 VSS g45n1svt m=1 l=45n w=205n
Mmn25 n21 D VSS VSS g45n1svt m=1 l=45n w=205n
Mmn55 Q qbint VSS VSS g45n1svt m=1 l=45n w=2.065u
Mmn50 net172 qbint VSS VSS g45n1svt m=1 l=45n w=205n
Mmn51 n30 CKb net172 VSS g45n1svt m=1 l=45n w=205n
Mmn30 mout n20 VSS VSS g45n1svt m=1 l=45n w=205n
Mmn36 n20 CKbb net192 VSS g45n1svt m=1 l=45n w=205n
Mmn20 CKb CK VSS VSS g45n1svt m=1 l=45n w=145n
Mmn45 qbint n30 VSS VSS g45n1svt m=1 l=45n w=780n
Mmn40 mout CKbb n30 VSS g45n1svt m=1 l=45n w=205n
Mmn21 CKbb CKb VSS VSS g45n1svt m=1 l=45n w=145n
Mmn35 net192 mout VSS VSS g45n1svt m=1 l=45n w=205n
Mmp26 n20 CKbb n22 VDD g45p1svt m=1 l=45n w=310n
Mmp25 n22 D VDD VDD g45p1svt m=1 l=45n w=310n
Mmp51 n30 CKbb net123 VDD g45p1svt m=1 l=45n w=310n
Mmp50 net123 qbint VDD VDD g45p1svt m=1 l=45n w=310n
Mmp55 Q qbint VDD VDD g45p1svt m=1 l=45n w=3.115u
Mmp35 net147 mout VDD VDD g45p1svt m=1 l=45n w=310n
Mmp36 n20 CKb net147 VDD g45p1svt m=1 l=45n w=310n
Mmp45 qbint n30 VDD VDD g45p1svt m=1 l=45n w=1.17u
Mmp20 CKb CK VDD VDD g45p1svt m=1 l=45n w=215n
Mmp40 mout CKb n30 VDD g45p1svt m=1 l=45n w=310n
Mmp30 mout n20 VDD VDD g45p1svt m=1 l=45n w=310n
Mmp21 CKbb CKb VDD VDD g45p1svt m=1 l=45n w=215n
.ENDS
