************************************************************************
* auCdl Netlist:
*
* Library Name:  gsclib045
* Top Cell Name: CLKBUFX20
* View Name:     schematic
* Netlisted on:  Jun  4 07:40:14 2012
************************************************************************

*.BIPOLAR
*.RESI = 2000
*.EQUATION
*.SCALE METER
*.MEGA
.PARAM

*.GLOBAL VDD:P
+        VSS:G
+        ExtVDD:P
+        ExtVSS:G

*.PIN VDD
*+    VSS
*+    ExtVDD
*+    ExtVSS

************************************************************************
* Library Name: gsclib045
* Cell Name:    CLKBUFX20
* View Name:    schematic
************************************************************************

.SUBCKT CLKBUFX20 A VDD VSS Y
*.PININFO A:I VDD:I VSS:I Y:O
Mmn1 Y net44 VSS VSS g45n1svt m=1 l=45n w=5.185u
Mmn0 net44 A VSS VSS g45n1svt m=1 l=45n w=1.3u
Mmp1 Y net44 VDD VDD g45p1svt m=1 l=45n w=7.815u
Mmp0 net44 A VDD VDD g45p1svt m=1 l=45n w=1.95u
.ENDS
