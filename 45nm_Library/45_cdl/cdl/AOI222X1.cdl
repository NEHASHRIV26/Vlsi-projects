************************************************************************
* auCdl Netlist:
*
* Library Name:  gsclib045
* Top Cell Name: AOI222X1
* View Name:     schematic
* Netlisted on:  Jun  4 07:38:53 2012
************************************************************************

*.BIPOLAR
*.RESI = 2000
*.EQUATION
*.SCALE METER
*.MEGA
.PARAM

*.GLOBAL VSS:G
+        VDD:P
+        ExtVDD:P
+        ExtVSS:G

*.PIN VSS
*+    VDD
*+    ExtVDD
*+    ExtVSS

************************************************************************
* Library Name: gsclib045
* Cell Name:    AOI222X1
* View Name:    schematic
************************************************************************

.SUBCKT AOI222X1 A0 A1 B0 B1 C0 C1 VDD VSS Y
*.PININFO A0:I A1:I B0:I B1:I C0:I C1:I VDD:I VSS:I Y:O
Mmn5 Y C1 net155 VSS g45n1svt m=1 l=45n w=260n
Mmn4 net155 C0 VSS VSS g45n1svt m=1 l=45n w=260n
Mmn2 net147 B0 VSS VSS g45n1svt m=1 l=45n w=260n
Mmn0 net139 A0 VSS VSS g45n1svt m=1 l=45n w=260n
Mmn1 Y A1 net139 VSS g45n1svt m=1 l=45n w=260n
Mmn3 Y B1 net147 VSS g45n1svt m=1 l=45n w=260n
Mmp5 Y C1 net118 VDD g45p1svt m=1 l=45n w=390n
Mmp4 Y C0 net118 VDD g45p1svt m=1 l=45n w=390n
Mmp3 net118 B1 net122 VDD g45p1svt m=1 l=45n w=390n
Mmp2 net118 B0 net122 VDD g45p1svt m=1 l=45n w=390n
Mmp0 net122 A0 VDD VDD g45p1svt m=1 l=45n w=390n
Mmp1 net122 A1 VDD VDD g45p1svt m=1 l=45n w=390n
.ENDS
