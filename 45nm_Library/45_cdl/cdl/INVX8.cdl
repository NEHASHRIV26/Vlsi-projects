************************************************************************
* auCdl Netlist:
*
* Library Name:  gsclib045
* Top Cell Name: INVX8
* View Name:     schematic
* Netlisted on:  Jun  4 07:43:16 2012
************************************************************************

*.BIPOLAR
*.RESI = 2000
*.EQUATION
*.SCALE METER
*.MEGA
.PARAM

*.GLOBAL VDD:P
+        VSS:G
+        ExtVDD:P
+        ExtVSS:G

*.PIN VDD
*+    VSS
*+    ExtVDD
*+    ExtVSS

************************************************************************
* Library Name: gsclib045
* Cell Name:    INVX8
* View Name:    schematic
************************************************************************

.SUBCKT INVX8 A VDD VSS Y
*.PININFO A:I VDD:I VSS:I Y:O
Mmp0 Y A VDD VDD g45p1svt m=1 l=45n w=3.115u
Mmn0 Y A VSS VSS g45n1svt m=1 l=45n w=2.065u
.ENDS
