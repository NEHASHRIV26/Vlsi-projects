************************************************************************
* auCdl Netlist:
*
* Library Name:  gsclib045
* Top Cell Name: OAI221X4
* View Name:     schematic
* Netlisted on:  Jun  4 07:47:20 2012
************************************************************************

*.BIPOLAR
*.RESI = 2000
*.EQUATION
*.SCALE METER
*.MEGA
.PARAM

*.GLOBAL VDD:P
+        VSS:G
+        ExtVDD:P
+        ExtVSS:G

*.PIN VDD
*+    VSS
*+    ExtVDD
*+    ExtVSS

************************************************************************
* Library Name: gsclib045
* Cell Name:    OAI221X4
* View Name:    schematic
************************************************************************

.SUBCKT OAI221X4 A0 A1 B0 B1 C0 VDD VSS Y
*.PININFO A0:I A1:I B0:I B1:I C0:I VDD:I VSS:I Y:O
Mmn4 Y C0 net132 VSS g45n1svt m=1 l=45n w=1.04u
Mmn0 net128 A0 VSS VSS g45n1svt m=1 l=45n w=1.04u
Mmn1 net128 A1 VSS VSS g45n1svt m=1 l=45n w=1.04u
Mmn2 net132 B0 net128 VSS g45n1svt m=1 l=45n w=1.04u
Mmn3 net132 B1 net128 VSS g45n1svt m=1 l=45n w=1.04u
Mmp3 Y B1 net123 VDD g45p1svt m=1 l=45n w=1.56u
Mmp0 net115 A0 VDD VDD g45p1svt m=1 l=45n w=1.56u
Mmp1 Y A1 net115 VDD g45p1svt m=1 l=45n w=1.56u
Mmp2 net123 B0 VDD VDD g45p1svt m=1 l=45n w=1.56u
Mmp4 Y C0 VDD VDD g45p1svt m=1 l=45n w=1.56u
.ENDS
