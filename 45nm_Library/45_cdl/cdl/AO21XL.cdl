************************************************************************
* auCdl Netlist:
*
* Library Name:  gsclib045
* Top Cell Name: AO21XL
* View Name:     schematic
* Netlisted on:  Jun  4 07:38:26 2012
************************************************************************

*.BIPOLAR
*.RESI = 2000
*.EQUATION
*.SCALE METER
*.MEGA
.PARAM

*.GLOBAL VDD:P
+        VSS:G
+        ExtVDD:P
+        ExtVSS:G

*.PIN VDD
*+    VSS
*+    ExtVDD
*+    ExtVSS

************************************************************************
* Library Name: gsclib045
* Cell Name:    AO21XL
* View Name:    schematic
************************************************************************

.SUBCKT AO21XL A0 A1 B0 VDD VSS Y
*.PININFO A0:I A1:I B0:I VDD:I VSS:I Y:O
Mmn1 n0 A1 n1 VSS g45n1svt m=1 l=45n w=145n
Mmn0 n1 A0 VSS VSS g45n1svt m=1 l=45n w=145n
Mmn3 Y n0 VSS VSS g45n1svt m=1 l=45n w=145n
Mmn2 n0 B0 VSS VSS g45n1svt m=1 l=45n w=145n
Mmp1 n2 A1 VDD VDD g45p1svt m=1 l=45n w=215n
Mmp0 n2 A0 VDD VDD g45p1svt m=1 l=45n w=215n
Mmp3 Y n0 VDD VDD g45p1svt m=1 l=45n w=215n
Mmp2 n0 B0 n2 VDD g45p1svt m=1 l=45n w=215n
.ENDS
