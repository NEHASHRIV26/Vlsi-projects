************************************************************************
* auCdl Netlist:
*
* Library Name:  gsclib045
* Top Cell Name: ISOLX1_OFF
* View Name:     schematic
* Netlisted on:  Jun  4 07:43:26 2012
************************************************************************

*.BIPOLAR
*.RESI = 2000
*.EQUATION
*.SCALE METER
*.MEGA
.PARAM

*.GLOBAL VDD:P
+        VSS:G
+        ExtVDD:P
+        ExtVSS:G

*.PIN VDD
*+    VSS
*+    ExtVDD
*+    ExtVSS

************************************************************************
* Library Name: gsclib045
* Cell Name:    ISOLX1_OFF
* View Name:    schematic
************************************************************************

.SUBCKT ISOLX1_OFF A ExtVDD ISO VDD VSS Y
*.PININFO A:I ExtVDD:I ISO:I VDD:I VSS:I Y:O
MNM1 VSS ISO ison VSS g45n1svt m=1 l=45n w=145n
Mmn2 Y n0 VSS VSS g45n1svt m=1 l=45n w=260n
Mmn0 net127 ison VSS VSS g45n1svt m=1 l=45n w=145n
Mmn1 n0 A net127 VSS g45n1svt m=1 l=45n w=145n
MPM1 ison ISO ExtVDD ExtVDD g45p1svt m=1 l=45n w=215n
Mmp1 n0 ison ExtVDD ExtVDD g45p1svt m=1 l=45n w=215n
Mmp0 n0 A ExtVDD ExtVDD g45p1svt m=1 l=45n w=215n
Mmp2 Y n0 ExtVDD ExtVDD g45p1svt m=1 l=45n w=390n
.ENDS
