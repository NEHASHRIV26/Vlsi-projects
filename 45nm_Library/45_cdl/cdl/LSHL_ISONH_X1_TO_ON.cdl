************************************************************************
* auCdl Netlist:
*
* Library Name:  gsclib045
* Top Cell Name: LSHL_ISONH_X1_TO_ON
* View Name:     schematic
* Netlisted on:  Jun  4 07:43:44 2012
************************************************************************

*.BIPOLAR
*.RESI = 2000
*.EQUATION
*.SCALE METER
*.MEGA
.PARAM

*.GLOBAL VSS:G
+        VDD:P
+        ExtVDD:P
+        ExtVSS:G

*.PIN VSS
*+    VDD
*+    ExtVDD
*+    ExtVSS

************************************************************************
* Library Name: gsclib045
* Cell Name:    LSHL_ISONH_X1_TO_ON
* View Name:    schematic
************************************************************************

.SUBCKT LSHL_ISONH_X1_TO_ON A ISOn VDD VSS Y
*.PININFO A:I ISOn:I VDD:I VSS:I Y:O
MNM3 gatedVSS ISOn VSS VSS g45n1svt m=1 l=45n w=520n
MNM0 Y n0 gatedVSS VSS g45n1svt m=1 l=45n w=260n
Mmn0 gatedVSS A n0 VSS g45n1svt m=1 l=45n w=145n
MPM4 Y ISOn VDD VDD g45p1svt m=1 l=45n w=390n
MPM0 Y n0 VDD VDD g45p1svt m=1 l=45n w=390n
Mmp0 n0 A VDD VDD g45p1svt m=1 l=45n w=215n
.ENDS
