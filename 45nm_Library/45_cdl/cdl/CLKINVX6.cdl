************************************************************************
* auCdl Netlist:
*
* Library Name:  gsclib045
* Top Cell Name: CLKINVX6
* View Name:     schematic
* Netlisted on:  Jun  4 07:40:33 2012
************************************************************************

*.BIPOLAR
*.RESI = 2000
*.EQUATION
*.SCALE METER
*.MEGA
.PARAM

*.GLOBAL VSS:G
+        VDD:P
+        ExtVDD:P
+        ExtVSS:G

*.PIN VSS
*+    VDD
*+    ExtVDD
*+    ExtVSS

************************************************************************
* Library Name: gsclib045
* Cell Name:    CLKINVX6
* View Name:    schematic
************************************************************************

.SUBCKT CLKINVX6 A VDD VSS Y
*.PININFO A:I VDD:I VSS:I Y:O
Mmp0 Y A VDD VDD g45p1svt m=1 l=45n w=2.35u
Mmn0 Y A VSS VSS g45n1svt m=1 l=45n w=1.55u
.ENDS
