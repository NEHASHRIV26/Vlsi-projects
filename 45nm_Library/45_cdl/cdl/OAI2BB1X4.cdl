************************************************************************
* auCdl Netlist:
*
* Library Name:  gsclib045
* Top Cell Name: OAI2BB1X4
* View Name:     schematic
* Netlisted on:  Jun  4 07:47:39 2012
************************************************************************

*.BIPOLAR
*.RESI = 2000
*.EQUATION
*.SCALE METER
*.MEGA
.PARAM

*.GLOBAL VSS:G
+        VDD:P
+        ExtVDD:P
+        ExtVSS:G

*.PIN VSS
*+    VDD
*+    ExtVDD
*+    ExtVSS

************************************************************************
* Library Name: gsclib045
* Cell Name:    OAI2BB1X4
* View Name:    schematic
************************************************************************

.SUBCKT OAI2BB1X4 A0N A1N B0 VDD VSS Y
*.PININFO A0N:I A1N:I B0:I VDD:I VSS:I Y:O
Mmn3 Y n0 n2 VSS g45n1svt m=1 l=45n w=1.04u
Mmn2 n2 B0 VSS VSS g45n1svt m=1 l=45n w=1.04u
Mmn0 n1 A0N VSS VSS g45n1svt m=1 l=45n w=260n
Mmn1 n0 A1N n1 VSS g45n1svt m=1 l=45n w=260n
Mmp2 Y B0 VDD VDD g45p1svt m=1 l=45n w=1.56u
Mmp1 n0 A1N VDD VDD g45p1svt m=1 l=45n w=390n
Mmp0 n0 A0N VDD VDD g45p1svt m=1 l=45n w=390n
Mmp3 Y n0 VDD VDD g45p1svt m=1 l=45n w=1.56u
.ENDS
