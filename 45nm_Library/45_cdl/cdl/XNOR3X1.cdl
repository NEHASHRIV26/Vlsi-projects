************************************************************************
* auCdl Netlist:
*
* Library Name:  gsclib045
* Top Cell Name: XNOR3X1
* View Name:     schematic
* Netlisted on:  Jun  4 07:52:34 2012
************************************************************************

*.BIPOLAR
*.RESI = 2000
*.EQUATION
*.SCALE METER
*.MEGA
.PARAM

*.GLOBAL VSS:G
+        VDD:P
+        ExtVDD:P
+        ExtVSS:G

*.PIN VSS
*+    VDD
*+    ExtVDD
*+    ExtVSS

************************************************************************
* Library Name: gsclib045
* Cell Name:    XNOR3X1
* View Name:    schematic
************************************************************************

.SUBCKT XNOR3X1 A B C VDD VSS Y
*.PININFO A:I B:I C:I VDD:I VSS:I Y:O
Mmn8 Y n11 VSS VSS g45n1svt m=1 l=45n w=205n
Mmn10 n12 n61 n8 VSS g45n1svt m=1 l=45n w=205n
Mmn2 n9 n61 n62 VSS g45n1svt m=1 l=45n w=205n
Mmn1 n9 B n8 VSS g45n1svt m=1 l=45n w=190n
Mmn9 n8 n62 VSS VSS g45n1svt m=1 l=45n w=190n
Mmn11 n12 B n62 VSS g45n1svt m=1 l=45n w=205n
Mmn6 n11 C n9 VSS g45n1svt m=1 l=45n w=190n
Mmn5 n11 n60 n12 VSS g45n1svt m=1 l=45n w=190n
Mmn7 n60 C VSS VSS g45n1svt m=1 l=45n w=190n
Mmn4 n61 B VSS VSS g45n1svt m=1 l=45n w=190n
Mmn3 n62 A VSS VSS g45n1svt m=1 l=45n w=205n
Mmp8 Y n11 VDD VDD g45p1svt m=1 l=45n w=390n
Mmp3 n62 A VDD VDD g45p1svt m=1 l=45n w=390n
Mmp6 n9 n60 n11 VDD g45p1svt m=1 l=45n w=310n
Mmp11 n62 n61 n12 VDD g45p1svt m=1 l=45n w=390n
Mmp2 n62 B n9 VDD g45p1svt m=1 l=45n w=390n
Mmp5 n12 C n11 VDD g45p1svt m=1 l=45n w=310n
Mmp1 n8 n61 n9 VDD g45p1svt m=1 l=45n w=310n
Mmp10 n8 B n12 VDD g45p1svt m=1 l=45n w=310n
Mmp4 n61 B VDD VDD g45p1svt m=1 l=45n w=310n
Mmp9 n8 n62 VDD VDD g45p1svt m=1 l=45n w=310n
Mmp7 n60 C VDD VDD g45p1svt m=1 l=45n w=310n
.ENDS
