************************************************************************
* auCdl Netlist:
*
* Library Name:  gsclib045
* Top Cell Name: DLY1X1
* View Name:     schematic
* Netlisted on:  Jun  4 07:42:05 2012
************************************************************************

*.BIPOLAR
*.RESI = 2000
*.EQUATION
*.SCALE METER
*.MEGA
.PARAM

*.GLOBAL VSS:G
+        VDD:P
+        ExtVDD:P
+        ExtVSS:G

*.PIN VSS
*+    VDD
*+    ExtVDD
*+    ExtVSS

************************************************************************
* Library Name: gsclib045
* Cell Name:    DLY1X1
* View Name:    schematic
************************************************************************

.SUBCKT DLY1X1 A VDD VSS Y
*.PININFO A:I VDD:I VSS:I Y:O
Mmn2 n1 VDD n4 VSS g45n1svt m=1 l=45n w=145n
Mmn1 n4 n0 VSS VSS g45n1svt m=1 l=45n w=145n
Mmn4 Y n2 VSS VSS g45n1svt m=1 l=45n w=260n
Mmn0 n0 A VSS VSS g45n1svt m=1 l=45n w=145n
Mmn3 n2 n1 VSS VSS g45n1svt m=1 l=45n w=145n
Mmp2 n1 VSS n5 VDD g45p1svt m=1 l=45n w=215n
Mmp1 n5 n0 VDD VDD g45p1svt m=1 l=45n w=215n
Mmp4 Y n2 VDD VDD g45p1svt m=1 l=45n w=390n
Mmp0 n0 A VDD VDD g45p1svt m=1 l=45n w=215n
Mmp3 n2 n1 VDD VDD g45p1svt m=1 l=45n w=215n
.ENDS
