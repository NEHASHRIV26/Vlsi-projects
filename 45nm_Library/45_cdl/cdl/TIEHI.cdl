************************************************************************
* auCdl Netlist:
*
* Library Name:  gsclib045
* Top Cell Name: TIEHI
* View Name:     schematic
* Netlisted on:  Jun  4 07:51:33 2012
************************************************************************

*.BIPOLAR
*.RESI = 2000
*.EQUATION
*.SCALE METER
*.MEGA
.PARAM

*.GLOBAL VSS:G
+        VDD:P
+        ExtVDD:P
+        ExtVSS:G

*.PIN VSS
*+    VDD
*+    ExtVDD
*+    ExtVSS

************************************************************************
* Library Name: gsclib045
* Cell Name:    TIEHI
* View Name:    schematic
************************************************************************

.SUBCKT TIEHI VDD VSS Y
*.PININFO VDD:I VSS:I Y:O
Mmp0 Y net25 VDD VDD g45p1svt m=1 l=45n w=390n
Mmn0 net25 net25 VSS VSS g45n1svt m=1 l=45n w=260n
.ENDS
