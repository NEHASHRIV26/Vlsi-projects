************************************************************************
* auCdl Netlist:
*
* Library Name:  gsclib045
* Top Cell Name: FILL64
* View Name:     schematic
* Netlisted on:  Jun  4 07:42:47 2012
************************************************************************

*.BIPOLAR
*.RESI = 2000
*.EQUATION
*.SCALE METER
*.MEGA
.PARAM

*.GLOBAL VDD:P
+        VSS:G
+        ExtVDD:P
+        ExtVSS:G

*.PIN VDD
*+    VSS
*+    ExtVDD
*+    ExtVSS

************************************************************************
* Library Name: gsclib045
* Cell Name:    FILL64
* View Name:    schematic
************************************************************************

.SUBCKT FILL64 VDD VSS
*.PININFO VDD:I VSS:I
.ENDS
