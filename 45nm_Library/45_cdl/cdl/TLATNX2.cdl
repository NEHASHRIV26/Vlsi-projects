************************************************************************
* auCdl Netlist:
*
* Library Name:  gsclib045
* Top Cell Name: TLATNX2
* View Name:     schematic
* Netlisted on:  Jun  4 07:52:10 2012
************************************************************************

*.BIPOLAR
*.RESI = 2000
*.EQUATION
*.SCALE METER
*.MEGA
.PARAM

*.GLOBAL VDD:P
+        VSS:G
+        ExtVDD:P
+        ExtVSS:G

*.PIN VDD
*+    VSS
*+    ExtVDD
*+    ExtVSS

************************************************************************
* Library Name: gsclib045
* Cell Name:    TLATNX2
* View Name:    schematic
************************************************************************

.SUBCKT TLATNX2 D GN Q QN VDD VSS
*.PININFO D:I GN:I VDD:I VSS:I Q:O QN:O
Mmn5 net257 D VSS VSS g45n1svt m=1 l=45n w=145n
Mmn6 n0 GNb net257 VSS g45n1svt m=1 l=45n w=145n
Mmn16 n0 GNbb net245 VSS g45n1svt m=1 l=45n w=145n
Mmn15 net245 Qint VSS VSS g45n1svt m=1 l=45n w=145n
Mmn22 QN Qint VSS VSS g45n1svt m=1 l=45n w=520n
Mmn21 Q Qbint VSS VSS g45n1svt m=1 l=45n w=520n
Mmn0 GNb GN VSS VSS g45n1svt m=1 l=45n w=145n
Mmn1 GNbb GNb VSS VSS g45n1svt m=1 l=45n w=145n
Mmn10 Qint n0 VSS VSS g45n1svt m=1 l=45n w=205n
Mmn20 Qbint Qint VSS VSS g45n1svt m=1 l=45n w=520n
Mmp6 n0 GNbb net220 VDD g45p1svt m=1 l=45n w=215n
Mmp5 net220 D VDD VDD g45p1svt m=1 l=45n w=215n
Mmp16 n0 GNb net212 VDD g45p1svt m=1 l=45n w=215n
Mmp15 net212 Qint VDD VDD g45p1svt m=1 l=45n w=215n
Mmp22 QN Qint VDD VDD g45p1svt m=1 l=45n w=780n
Mmp21 Q Qbint VDD VDD g45p1svt m=1 l=45n w=780n
Mmp0 GNb GN VDD VDD g45p1svt m=1 l=45n w=215n
Mmp1 GNbb GNb VDD VDD g45p1svt m=1 l=45n w=215n
Mmp10 Qint n0 VDD VDD g45p1svt m=1 l=45n w=310n
Mmp20 Qbint Qint VDD VDD g45p1svt m=1 l=45n w=780n
.ENDS
