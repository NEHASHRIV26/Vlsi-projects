************************************************************************
* auCdl Netlist:
*
* Library Name:  gsclib045
* Top Cell Name: AOI32X1
* View Name:     schematic
* Netlisted on:  Jun  4 07:39:30 2012
************************************************************************

*.BIPOLAR
*.RESI = 2000
*.EQUATION
*.SCALE METER
*.MEGA
.PARAM

*.GLOBAL VSS:G
+        VDD:P
+        ExtVDD:P
+        ExtVSS:G

*.PIN VSS
*+    VDD
*+    ExtVDD
*+    ExtVSS

************************************************************************
* Library Name: gsclib045
* Cell Name:    AOI32X1
* View Name:    schematic
************************************************************************

.SUBCKT AOI32X1 A0 A1 A2 B0 B1 VDD VSS Y
*.PININFO A0:I A1:I A2:I B0:I B1:I VDD:I VSS:I Y:O
Mmn3 net118 B0 VSS VSS g45n1svt m=1 l=45n w=260n
Mmn2 Y A2 net126 VSS g45n1svt m=1 l=45n w=260n
Mmn0 net122 A0 VSS VSS g45n1svt m=1 l=45n w=260n
Mmn1 net126 A1 net122 VSS g45n1svt m=1 l=45n w=260n
Mmn4 Y B1 net118 VSS g45n1svt m=1 l=45n w=260n
Mmp3 Y B0 net114 VDD g45p1svt m=1 l=45n w=390n
Mmp4 Y B1 net114 VDD g45p1svt m=1 l=45n w=390n
Mmp2 net114 A2 VDD VDD g45p1svt m=1 l=45n w=390n
Mmp1 net114 A1 VDD VDD g45p1svt m=1 l=45n w=390n
Mmp0 net114 A0 VDD VDD g45p1svt m=1 l=45n w=390n
.ENDS
