************************************************************************
* auCdl Netlist:
*
* Library Name:  gsclib045
* Top Cell Name: DFFNSRX4
* View Name:     schematic
* Netlisted on:  Jun  4 07:41:03 2012
************************************************************************

*.BIPOLAR
*.RESI = 2000
*.EQUATION
*.SCALE METER
*.MEGA
.PARAM

*.GLOBAL VDD:P
+        VSS:G
+        ExtVDD:P
+        ExtVSS:G

*.PIN VDD
*+    VSS
*+    ExtVDD
*+    ExtVSS

************************************************************************
* Library Name: gsclib045
* Cell Name:    DFFNSRX4
* View Name:    schematic
************************************************************************

.SUBCKT DFFNSRX4 CKN D Q QN RN SN VDD VSS
*.PININFO CKN:I D:I RN:I SN:I VDD:I VSS:I Q:O QN:O
Mmn26 n20 CKNbb n21 VSS g45n1svt m=1 l=45n w=145n
Mmn25 n21 D VSS VSS g45n1svt m=1 l=45n w=145n
Mmn57 QN qint VSS VSS g45n1svt m=1 l=45n w=1.04u
Mmn55 Q qbint VSS VSS g45n1svt m=1 l=45n w=1.04u
Mmn36 n20 CKNb n30 VSS g45n1svt m=1 l=45n w=145n
Mmn35 n30 mout VSS VSS g45n1svt m=1 l=45n w=145n
Mmn22 RNb RN VSS VSS g45n1svt m=1 l=45n w=145n
Mmn20 CKNb CKN VSS VSS g45n1svt m=1 l=45n w=145n
Mmn45 qbint n35 VSS VSS g45n1svt m=1 l=45n w=410n
Mmn56 qint qbint VSS VSS g45n1svt m=1 l=45n w=260n
Mmn52 n40 qbint n42 VSS g45n1svt m=1 l=45n w=145n
Mmn51 n40 RNb n42 VSS g45n1svt m=1 l=45n w=145n
Mmn50 n42 SN VSS VSS g45n1svt m=1 l=45n w=145n
Mmn53 n40 CKNbb n35 VSS g45n1svt m=1 l=45n w=145n
Mmn21 CKNbb CKNb VSS VSS g45n1svt m=1 l=45n w=145n
Mmn32 mout n20 n25 VSS g45n1svt m=1 l=45n w=145n
Mmn31 n25 RNb mout VSS g45n1svt m=1 l=45n w=145n
Mmn30 n25 SN VSS VSS g45n1svt m=1 l=45n w=145n
Mmn40 n35 CKNb mout VSS g45n1svt m=1 l=45n w=145n
Mmp25 n22 D VDD VDD g45p1svt m=1 l=45n w=215n
Mmp26 n20 CKNb n22 VDD g45p1svt m=1 l=45n w=215n
Mmp51 n43 RNb VDD VDD g45p1svt m=1 l=45n w=215n
Mmp57 QN qint VDD VDD g45p1svt m=1 l=45n w=1.56u
Mmp55 Q qbint VDD VDD g45p1svt m=1 l=45n w=1.56u
Mmp36 n20 CKNbb n31 VDD g45p1svt m=1 l=45n w=215n
Mmp35 n31 mout VDD VDD g45p1svt m=1 l=45n w=215n
Mmp32 mout n20 n26 VDD g45p1svt m=1 l=45n w=215n
Mmp31 n26 RNb VDD VDD g45p1svt m=1 l=45n w=215n
Mmp22 RNb RN VDD VDD g45p1svt m=1 l=45n w=215n
Mmp20 CKNb CKN VDD VDD g45p1svt m=1 l=45n w=215n
Mmp53 n41 CKNb n35 VDD g45p1svt m=1 l=45n w=215n
Mmp50 n41 SN VDD VDD g45p1svt m=1 l=45n w=215n
Mmp45 qbint n35 VDD VDD g45p1svt m=1 l=45n w=620n
Mmp56 qint qbint VDD VDD g45p1svt m=1 l=45n w=390n
Mmp21 CKNbb CKNb VDD VDD g45p1svt m=1 l=45n w=215n
Mmp40 n35 CKNbb mout VDD g45p1svt m=1 l=45n w=215n
Mmp52 n41 qbint n43 VDD g45p1svt m=1 l=45n w=215n
Mmp30 mout SN VDD VDD g45p1svt m=1 l=45n w=215n
.ENDS
