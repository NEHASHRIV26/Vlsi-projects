************************************************************************
* auCdl Netlist:
*
* Library Name:  gsclib045
* Top Cell Name: LSHLX1_FROM
* View Name:     schematic
* Netlisted on:  Jun  4 07:43:33 2012
************************************************************************

*.BIPOLAR
*.RESI = 2000
*.EQUATION
*.SCALE METER
*.MEGA
.PARAM

*.GLOBAL VSS:G
+        VDD:P
+        ExtVDD:P
+        ExtVSS:G

*.PIN VSS
*+    VDD
*+    ExtVDD
*+    ExtVSS

************************************************************************
* Library Name: gsclib045
* Cell Name:    LSHLX1_FROM
* View Name:    schematic
************************************************************************

.SUBCKT LSHLX1_FROM A ExtVDD VDD VSS Y
*.PININFO A:I ExtVDD:I VDD:I VSS:I Y:O
MNM0 Y n0 VSS VSS g45n1svt m=1 l=45n w=260n
Mmn0 n0 A VSS VSS g45n1svt m=1 l=45n w=145n
MPM0 Y n0 ExtVDD ExtVDD g45p1svt m=1 l=45n w=390n
Mmp0 n0 A ExtVDD ExtVDD g45p1svt m=1 l=45n w=215n
.ENDS
