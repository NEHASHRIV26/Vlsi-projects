************************************************************************
* auCdl Netlist:
*
* Library Name:  gsclib045
* Top Cell Name: OR4X1
* View Name:     schematic
* Netlisted on:  Jun  4 07:48:29 2012
************************************************************************

*.BIPOLAR
*.RESI = 2000
*.EQUATION
*.SCALE METER
*.MEGA
.PARAM

*.GLOBAL VSS:G
+        VDD:P
+        ExtVDD:P
+        ExtVSS:G

*.PIN VSS
*+    VDD
*+    ExtVDD
*+    ExtVSS

************************************************************************
* Library Name: gsclib045
* Cell Name:    OR4X1
* View Name:    schematic
************************************************************************

.SUBCKT OR4X1 A B C D VDD VSS Y
*.PININFO A:I B:I C:I D:I VDD:I VSS:I Y:O
Mmn4 Y n0 VSS VSS g45n1svt m=1 l=45n w=260n
Mmn3 n0 D VSS VSS g45n1svt m=1 l=45n w=145n
Mmn0 n0 A VSS VSS g45n1svt m=1 l=45n w=145n
Mmn2 n0 C VSS VSS g45n1svt m=1 l=45n w=145n
Mmn1 n0 B VSS VSS g45n1svt m=1 l=45n w=145n
Mmp4 Y n0 VDD VDD g45p1svt m=1 l=45n w=390n
Mmp0 n1 A VDD VDD g45p1svt m=1 l=45n w=215n
Mmp3 n0 D n3 VDD g45p1svt m=1 l=45n w=215n
Mmp1 n2 B n1 VDD g45p1svt m=1 l=45n w=215n
Mmp2 n3 C n2 VDD g45p1svt m=1 l=45n w=215n
.ENDS
