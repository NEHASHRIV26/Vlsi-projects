************************************************************************
* auCdl Netlist:
*
* Library Name:  gsclib045
* Top Cell Name: NOR2X1
* View Name:     schematic
* Netlisted on:  Jun  4 07:46:03 2012
************************************************************************

*.BIPOLAR
*.RESI = 2000
*.EQUATION
*.SCALE METER
*.MEGA
.PARAM

*.GLOBAL VSS:G
+        VDD:P
+        ExtVDD:P
+        ExtVSS:G

*.PIN VSS
*+    VDD
*+    ExtVDD
*+    ExtVSS

************************************************************************
* Library Name: gsclib045
* Cell Name:    NOR2X1
* View Name:    schematic
************************************************************************

.SUBCKT NOR2X1 A B VDD VSS Y
*.PININFO A:I B:I VDD:I VSS:I Y:O
*.GROUNDSENSITIVITY VDD VSS
*.POWERSENSITIVITY VSS VDD
Mmn1 Y B VSS VSS g45n1svt m=1 l=45n w=260n
Mmn0 Y A VSS VSS g45n1svt m=1 l=45n w=260n
Mmp1 Y B net41 VDD g45p1svt m=1 l=45n w=390n
Mmp0 net41 A VDD VDD g45p1svt m=1 l=45n w=390n
.ENDS
