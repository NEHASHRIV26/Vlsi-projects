************************************************************************
* auCdl Netlist:
*
* Library Name:  gsclib045
* Top Cell Name: AND4X4
* View Name:     schematic
* Netlisted on:  Jun  4 07:38:14 2012
************************************************************************

*.BIPOLAR
*.RESI = 2000
*.EQUATION
*.SCALE METER
*.MEGA
.PARAM

*.GLOBAL VDD:P
+        VSS:G
+        ExtVDD:P
+        ExtVSS:G

*.PIN VDD
*+    VSS
*+    ExtVDD
*+    ExtVSS

************************************************************************
* Library Name: gsclib045
* Cell Name:    AND4X4
* View Name:    schematic
************************************************************************

.SUBCKT AND4X4 A B C D VDD VSS Y
*.PININFO A:I B:I C:I D:I VDD:I VSS:I Y:O
Mmn3 net100 D net132 VSS g45n1svt m=1 l=45n w=260n
Mmn2 net132 C net124 VSS g45n1svt m=1 l=45n w=260n
Mmn4 Y net100 VSS VSS g45n1svt m=1 l=45n w=1.04u
Mmn1 net124 B net120 VSS g45n1svt m=1 l=45n w=260n
Mmn0 net120 A VSS VSS g45n1svt m=1 l=45n w=260n
Mmp3 net100 D VDD VDD g45p1svt m=1 l=45n w=390n
Mmp2 net100 C VDD VDD g45p1svt m=1 l=45n w=390n
Mmp1 net100 B VDD VDD g45p1svt m=1 l=45n w=390n
Mmp4 Y net100 VDD VDD g45p1svt m=1 l=45n w=1.56u
Mmp0 net100 A VDD VDD g45p1svt m=1 l=45n w=390n
.ENDS
