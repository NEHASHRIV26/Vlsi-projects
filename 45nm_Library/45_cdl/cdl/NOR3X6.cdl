************************************************************************
* auCdl Netlist:
*
* Library Name:  gsclib045
* Top Cell Name: NOR3X6
* View Name:     schematic
* Netlisted on:  Jun  4 07:46:23 2012
************************************************************************

*.BIPOLAR
*.RESI = 2000
*.EQUATION
*.SCALE METER
*.MEGA
.PARAM

*.GLOBAL VSS:G
+        VDD:P
+        ExtVDD:P
+        ExtVSS:G

*.PIN VSS
*+    VDD
*+    ExtVDD
*+    ExtVSS

************************************************************************
* Library Name: gsclib045
* Cell Name:    NOR3X6
* View Name:    schematic
************************************************************************

.SUBCKT NOR3X6 A B C VDD VSS Y
*.PININFO A:I B:I C:I VDD:I VSS:I Y:O
Mmn0 Y A VSS VSS g45n1svt m=1 l=45n w=1.55u
Mmn1 Y B VSS VSS g45n1svt m=1 l=45n w=1.55u
Mmn2 Y C VSS VSS g45n1svt m=1 l=45n w=1.55u
Mmp1 n1 B n0 VDD g45p1svt m=1 l=45n w=2.34u
Mmp2 Y C n1 VDD g45p1svt m=1 l=45n w=2.34u
Mmp0 n0 A VDD VDD g45p1svt m=1 l=45n w=2.34u
.ENDS
