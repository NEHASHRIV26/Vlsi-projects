************************************************************************
* auCdl Netlist:
*
* Library Name:  gsclib045
* Top Cell Name: ISOLX1_ON
* View Name:     schematic
* Netlisted on:  Jun  4 07:43:28 2012
************************************************************************

*.BIPOLAR
*.RESI = 2000
*.EQUATION
*.SCALE METER
*.MEGA
.PARAM

*.GLOBAL VDD:P
+        VSS:G
+        ExtVDD:P
+        ExtVSS:G

*.PIN VDD
*+    VSS
*+    ExtVDD
*+    ExtVSS

************************************************************************
* Library Name: gsclib045
* Cell Name:    ISOLX1_ON
* View Name:    schematic
************************************************************************

.SUBCKT ISOLX1_ON A ISO VDD VSS Y
*.PININFO A:I ISO:I VDD:I VSS:I Y:O
MNM1 VSS ISO ison VSS g45n1svt m=1 l=45n w=145n
Mmn2 Y n0 VSS VSS g45n1svt m=1 l=45n w=260n
Mmn0 net127 ison VSS VSS g45n1svt m=1 l=45n w=145n
Mmn1 n0 A net127 VSS g45n1svt m=1 l=45n w=145n
MPM1 ison ISO VDD VDD g45p1svt m=1 l=45n w=215n
Mmp1 n0 ison VDD VDD g45p1svt m=1 l=45n w=215n
Mmp0 n0 A VDD VDD g45p1svt m=1 l=45n w=215n
Mmp2 Y n0 VDD VDD g45p1svt m=1 l=45n w=390n
.ENDS
