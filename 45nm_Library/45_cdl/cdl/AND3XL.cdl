************************************************************************
* auCdl Netlist:
*
* Library Name:  gsclib045
* Top Cell Name: AND3XL
* View Name:     schematic
* Netlisted on:  Jun  4 07:38:09 2012
************************************************************************

*.BIPOLAR
*.RESI = 2000
*.EQUATION
*.SCALE METER
*.MEGA
.PARAM

*.GLOBAL VDD:P
+        VSS:G
+        ExtVDD:P
+        ExtVSS:G

*.PIN VDD
*+    VSS
*+    ExtVDD
*+    ExtVSS

************************************************************************
* Library Name: gsclib045
* Cell Name:    AND3XL
* View Name:    schematic
************************************************************************

.SUBCKT AND3XL A B C VDD VSS Y
*.PININFO A:I B:I C:I VDD:I VSS:I Y:O
Mmn3 Y net87 VSS VSS g45n1svt m=1 l=45n w=145n
Mmn1 net107 B net103 VSS g45n1svt m=1 l=45n w=145n
Mmn0 net103 A VSS VSS g45n1svt m=1 l=45n w=145n
Mmn2 net87 C net107 VSS g45n1svt m=1 l=45n w=145n
Mmp1 net87 B VDD VDD g45p1svt m=1 l=45n w=215n
Mmp2 net87 C VDD VDD g45p1svt m=1 l=45n w=215n
Mmp0 net87 A VDD VDD g45p1svt m=1 l=45n w=215n
Mmp3 Y net87 VDD VDD g45p1svt m=1 l=45n w=215n
.ENDS
