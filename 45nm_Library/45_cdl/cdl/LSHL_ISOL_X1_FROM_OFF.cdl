************************************************************************
* auCdl Netlist:
*
* Library Name:  gsclib045
* Top Cell Name: LSHL_ISOL_X1_FROM_OFF
* View Name:     schematic
* Netlisted on:  Jun  4 07:43:40 2012
************************************************************************

*.BIPOLAR
*.RESI = 2000
*.EQUATION
*.SCALE METER
*.MEGA
.PARAM

*.GLOBAL VSS:G
+        VDD:P
+        ExtVDD:P
+        ExtVSS:G

*.PIN VSS
*+    VDD
*+    ExtVDD
*+    ExtVSS

************************************************************************
* Library Name: gsclib045
* Cell Name:    LSHL_ISOL_X1_FROM_OFF
* View Name:    schematic
************************************************************************

.SUBCKT LSHL_ISOL_X1_FROM_OFF A ExtVDD ISO VDD VSS Y
*.PININFO A:I ExtVDD:I ISO:I VDD:I VSS:I Y:O
MNM1 VSS ISO ison VSS g45n1svt m=1 l=45n w=145n
MNM3 GatedVSS ison VSS VSS g45n1svt m=1 l=45n w=520n
MNM0 Y n0 VSS VSS g45n1svt m=1 l=45n w=260n
Mmn0 GatedVSS A n0 VSS g45n1svt m=1 l=45n w=145n
MPM1 ison ISO ExtVDD ExtVDD g45p1svt m=1 l=45n w=215n
MPM2 n0 ison ExtVDD ExtVDD g45p1svt m=1 l=45n w=215n
MPM0 Y n0 ExtVDD ExtVDD g45p1svt m=1 l=45n w=390n
Mmp0 n0 A ExtVDD ExtVDD g45p1svt m=1 l=45n w=215n
.ENDS
