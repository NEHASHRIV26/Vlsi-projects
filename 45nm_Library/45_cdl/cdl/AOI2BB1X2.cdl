************************************************************************
* auCdl Netlist:
*
* Library Name:  gsclib045
* Top Cell Name: AOI2BB1X2
* View Name:     schematic
* Netlisted on:  Jun  4 07:39:10 2012
************************************************************************

*.BIPOLAR
*.RESI = 2000
*.EQUATION
*.SCALE METER
*.MEGA
.PARAM

*.GLOBAL VDD:P
+        VSS:G
+        ExtVDD:P
+        ExtVSS:G

*.PIN VDD
*+    VSS
*+    ExtVDD
*+    ExtVSS

************************************************************************
* Library Name: gsclib045
* Cell Name:    AOI2BB1X2
* View Name:    schematic
************************************************************************

.SUBCKT AOI2BB1X2 A0N A1N B0 VDD VSS Y
*.PININFO A0N:I A1N:I B0:I VDD:I VSS:I Y:O
Mmn2 Y B0 VSS VSS g45n1svt m=1 l=45n w=520n
Mmn1 net104 A1N VSS VSS g45n1svt m=1 l=45n w=145n
Mmn3 Y net104 VSS VSS g45n1svt m=1 l=45n w=520n
Mmn0 net104 A0N VSS VSS g45n1svt m=1 l=45n w=145n
Mmp3 Y net104 net79 VDD g45p1svt m=1 l=45n w=780n
Mmp2 net79 B0 VDD VDD g45p1svt m=1 l=45n w=780n
Mmp1 net104 A1N net87 VDD g45p1svt m=1 l=45n w=215n
Mmp0 net87 A0N VDD VDD g45p1svt m=1 l=45n w=215n
.ENDS
