************************************************************************
* auCdl Netlist:
*
* Library Name:  gsclib045
* Top Cell Name: RDFFNQX1
* View Name:     schematic
* Netlisted on:  Jun  4 07:48:43 2012
************************************************************************

*.BIPOLAR
*.RESI = 2000
*.EQUATION
*.SCALE METER
*.MEGA
.PARAM

*.GLOBAL VDD:P
+        ExtVDD:P
+        VSS:G
+        ExtVSS:G

*.PIN VDD
*+    ExtVDD
*+    VSS
*+    ExtVSS

************************************************************************
* Library Name: gsclib045
* Cell Name:    RDFFNQX1
* View Name:    schematic
************************************************************************

.SUBCKT RDFFNQX1 CKN D ExtVDD Q RT VDD VSS
*.PININFO CKN:I D:I ExtVDD:I RT:I VDD:I VSS:I Q:O
*.POWERSENSITIVITY VSS VDD
*.GROUNDSENSITIVITY VDD VSS
MNM3 net0121 qbint VSS VSS g45n1svt m=1 l=45n w=145n
MNM2 n35g RT net0121 VSS g45n1svt m=1 l=45n w=145n
MNM1 qbint n35g VSS VSS g45n1svt m=1 l=45n w=145n
MNM0 n35g RTb n35 VSS g45n1svt m=1 l=45n w=145n
Mmn26 n20 CKNbb n21 VSS g45n1svt m=1 l=45n w=145n
Mmn25 n21 D VSS VSS g45n1svt m=1 l=45n w=145n
Mmn55 Q qbint VSS VSS g45n1svt m=1 l=45n w=260n
Mmn35 n30 mout VSS VSS g45n1svt m=1 l=45n w=145n
Mmn36 n20 CKNb n30 VSS g45n1svt m=1 l=45n w=145n
Mmn20 CKNb CKN VSS VSS g45n1svt m=1 l=45n w=145n
Mmn45 RTb RT VSS VSS g45n1svt m=1 l=45n w=145n
Mmn52 net095 qbint VSS VSS g45n1svt m=1 l=45n w=145n
Mmn53 n35 CKNbb net095 VSS g45n1svt m=1 l=45n w=145n
Mmn21 CKNbb CKNb VSS VSS g45n1svt m=1 l=45n w=145n
Mmn32 mout n20 VSS VSS g45n1svt m=1 l=45n w=145n
Mmn40 n35 CKNb mout VSS g45n1svt m=1 l=45n w=145n
MPM3 n35g RTb net205 ExtVDD g45p1svt m=1 l=45n w=215n
MPM2 net205 qbint ExtVDD ExtVDD g45p1svt m=1 l=45n w=215n
MPM1 qbint n35g ExtVDD ExtVDD g45p1svt m=1 l=45n w=215n
MPM0 n35g RT n35 ExtVDD g45p1svt m=1 l=45n w=215n
Mmp26 n20 CKNb n22 VDD g45p1svt m=1 l=45n w=215n
Mmp25 n22 D VDD VDD g45p1svt m=1 l=45n w=215n
Mmp52 net082 qbint VDD VDD g45p1svt m=1 l=45n w=215n
Mmp55 Q qbint VDD VDD g45p1svt m=1 l=45n w=390n
Mmp36 n20 CKNbb n31 VDD g45p1svt m=1 l=45n w=215n
Mmp35 n31 mout VDD VDD g45p1svt m=1 l=45n w=215n
Mmp32 mout n20 VDD VDD g45p1svt m=1 l=45n w=215n
Mmp20 CKNb CKN VDD VDD g45p1svt m=1 l=45n w=215n
Mmp53 n35 CKNb net082 VDD g45p1svt m=1 l=45n w=215n
Mmp45 RTb RT ExtVDD ExtVDD g45p1svt m=1 l=45n w=215n
Mmp21 CKNbb CKNb VDD VDD g45p1svt m=1 l=45n w=215n
Mmp40 n35 CKNbb mout VDD g45p1svt m=1 l=45n w=215n
.ENDS
