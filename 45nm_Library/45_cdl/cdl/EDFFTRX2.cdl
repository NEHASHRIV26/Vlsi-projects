************************************************************************
* auCdl Netlist:
*
* Library Name:  gsclib045
* Top Cell Name: EDFFTRX2
* View Name:     schematic
* Netlisted on:  Jun  4 07:42:27 2012
************************************************************************

*.BIPOLAR
*.RESI = 2000
*.EQUATION
*.SCALE METER
*.MEGA
.PARAM

*.GLOBAL VSS:G
+        VDD:P
+        ExtVDD:P
+        ExtVSS:G

*.PIN VSS
*+    VDD
*+    ExtVDD
*+    ExtVSS

************************************************************************
* Library Name: gsclib045
* Cell Name:    EDFFTRX2
* View Name:    schematic
************************************************************************

.SUBCKT EDFFTRX2 CK D E Q QN RN VDD VSS
*.PININFO CK:I D:I E:I RN:I VDD:I VSS:I Q:O QN:O
Mmn35 net516 mout VSS VSS g45n1svt m=1 l=45n w=145n
Mmn36 n20 CKbb net516 VSS g45n1svt m=1 l=45n w=145n
Mmn26 n20 CKb n21 VSS g45n1svt m=1 l=45n w=145n
Mmn25 n21 Dp VSS VSS g45n1svt m=1 l=45n w=145n
Mmn51 n30 CKb net496 VSS g45n1svt m=1 l=45n w=145n
Mmn50 net496 qbint VSS VSS g45n1svt m=1 l=45n w=145n
Mmn57 QN qint VSS VSS g45n1svt m=1 l=45n w=520n
Mmn55 Q qbint VSS VSS g45n1svt m=1 l=45n w=520n
Mmn5 Dp qbint n0 VSS g45n1svt m=1 l=45n w=145n
Mmn4 n0 Eb VSS VSS g45n1svt m=1 l=45n w=145n
Mmn6 n1 E VSS VSS g45n1svt m=1 l=45n w=145n
Mmn7 Dp Db n1 VSS g45n1svt m=1 l=45n w=145n
Mmn20 CKb CK VSS VSS g45n1svt m=1 l=45n w=145n
Mmn2 RNb RN VSS VSS g45n1svt m=1 l=45n w=145n
Mmn1 Db D VSS VSS g45n1svt m=1 l=45n w=145n
Mmn30 mout n20 VSS VSS g45n1svt m=1 l=45n w=145n
Mmn21 CKbb CKb VSS VSS g45n1svt m=1 l=45n w=145n
Mmn40 n30 CKbb mout VSS g45n1svt m=1 l=45n w=145n
Mmn45 qbint n30 VSS VSS g45n1svt m=1 l=45n w=260n
Mmn56 qint qbint VSS VSS g45n1svt m=1 l=45n w=145n
Mmn3 Dp RNb VSS VSS g45n1svt m=1 l=45n w=145n
Mmn0 Eb E VSS VSS g45n1svt m=1 l=45n w=145n
Mmp25 n22 Dp VDD VDD g45p1svt m=1 l=45n w=215n
Mmp26 n20 CKbb n22 VDD g45p1svt m=1 l=45n w=215n
Mmp35 net427 mout VDD VDD g45p1svt m=1 l=45n w=215n
Mmp36 n20 CKb net427 VDD g45p1svt m=1 l=45n w=215n
Mmp51 n30 CKbb net411 VDD g45p1svt m=1 l=45n w=215n
Mmp50 net411 qbint VDD VDD g45p1svt m=1 l=45n w=215n
Mmp57 QN qint VDD VDD g45p1svt m=1 l=45n w=780n
Mmp55 Q qbint VDD VDD g45p1svt m=1 l=45n w=780n
Mmp20 CKb CK VDD VDD g45p1svt m=1 l=45n w=215n
Mmp2 RNb RN VDD VDD g45p1svt m=1 l=45n w=215n
Mmp1 Db D VDD VDD g45p1svt m=1 l=45n w=215n
Mmp7 Dp Db n3 VDD g45p1svt m=1 l=45n w=215n
Mmp6 Dp E n3 VDD g45p1svt m=1 l=45n w=215n
Mmp30 mout n20 VDD VDD g45p1svt m=1 l=45n w=215n
Mmp21 CKbb CKb VDD VDD g45p1svt m=1 l=45n w=215n
Mmp40 n30 CKb mout VDD g45p1svt m=1 l=45n w=215n
Mmp45 qbint n30 VDD VDD g45p1svt m=1 l=45n w=390n
Mmp56 qint qbint VDD VDD g45p1svt m=1 l=45n w=215n
Mmp5 n3 qbint n2 VDD g45p1svt m=1 l=45n w=215n
Mmp0 Eb E VDD VDD g45p1svt m=1 l=45n w=215n
Mmp4 n3 Eb n2 VDD g45p1svt m=1 l=45n w=215n
Mmp3 n2 RNb VDD VDD g45p1svt m=1 l=45n w=215n
.ENDS
