************************************************************************
* auCdl Netlist:
*
* Library Name:  gsclib045
* Top Cell Name: NOR3BX4
* View Name:     schematic
* Netlisted on:  Jun  4 07:46:15 2012
************************************************************************

*.BIPOLAR
*.RESI = 2000
*.EQUATION
*.SCALE METER
*.MEGA
.PARAM

*.GLOBAL VDD:P
+        VSS:G
+        ExtVDD:P
+        ExtVSS:G

*.PIN VDD
*+    VSS
*+    ExtVDD
*+    ExtVSS

************************************************************************
* Library Name: gsclib045
* Cell Name:    NOR3BX4
* View Name:    schematic
************************************************************************

.SUBCKT NOR3BX4 AN B C VDD VSS Y
*.PININFO AN:I B:I C:I VDD:I VSS:I Y:O
Mmn1 Y net91 VSS VSS g45n1svt m=1 l=45n w=1.04u
Mmn3 Y C VSS VSS g45n1svt m=1 l=45n w=1.04u
Mmn0 net91 AN VSS VSS g45n1svt m=1 l=45n w=260n
Mmn2 Y B VSS VSS g45n1svt m=1 l=45n w=1.04u
Mmp3 Y C net90 VDD g45p1svt m=1 l=45n w=1.56u
Mmp0 net91 AN VDD VDD g45p1svt m=1 l=45n w=390n
Mmp1 net86 net91 VDD VDD g45p1svt m=1 l=45n w=1.56u
Mmp2 net90 B net86 VDD g45p1svt m=1 l=45n w=1.56u
.ENDS
