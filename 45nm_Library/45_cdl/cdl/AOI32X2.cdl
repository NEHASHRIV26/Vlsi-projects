************************************************************************
* auCdl Netlist:
*
* Library Name:  gsclib045
* Top Cell Name: AOI32X2
* View Name:     schematic
* Netlisted on:  Jun  4 07:39:32 2012
************************************************************************

*.BIPOLAR
*.RESI = 2000
*.EQUATION
*.SCALE METER
*.MEGA
.PARAM

*.GLOBAL VSS:G
+        VDD:P
+        ExtVDD:P
+        ExtVSS:G

*.PIN VSS
*+    VDD
*+    ExtVDD
*+    ExtVSS

************************************************************************
* Library Name: gsclib045
* Cell Name:    AOI32X2
* View Name:    schematic
************************************************************************

.SUBCKT AOI32X2 A0 A1 A2 B0 B1 VDD VSS Y
*.PININFO A0:I A1:I A2:I B0:I B1:I VDD:I VSS:I Y:O
Mmn3 net83 B0 VSS VSS g45n1svt m=1 l=45n w=520n
Mmn2 Y A2 net71 VSS g45n1svt m=1 l=45n w=520n
Mmn0 net75 A0 VSS VSS g45n1svt m=1 l=45n w=520n
Mmn1 net71 A1 net75 VSS g45n1svt m=1 l=45n w=520n
Mmn4 Y B1 net83 VSS g45n1svt m=1 l=45n w=520n
Mmp3 Y B0 net47 VDD g45p1svt m=1 l=45n w=780n
Mmp4 Y B1 net47 VDD g45p1svt m=1 l=45n w=780n
Mmp2 net47 A2 VDD VDD g45p1svt m=1 l=45n w=780n
Mmp1 net47 A1 VDD VDD g45p1svt m=1 l=45n w=780n
Mmp0 net47 A0 VDD VDD g45p1svt m=1 l=45n w=780n
.ENDS
