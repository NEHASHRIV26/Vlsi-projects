************************************************************************
* auCdl Netlist:
*
* Library Name:  gsclib045
* Top Cell Name: NOR4BX2
* View Name:     schematic
* Netlisted on:  Jun  4 07:46:36 2012
************************************************************************

*.BIPOLAR
*.RESI = 2000
*.EQUATION
*.SCALE METER
*.MEGA
.PARAM

*.GLOBAL VSS:G
+        VDD:P
+        ExtVDD:P
+        ExtVSS:G

*.PIN VSS
*+    VDD
*+    ExtVDD
*+    ExtVSS

************************************************************************
* Library Name: gsclib045
* Cell Name:    NOR4BX2
* View Name:    schematic
************************************************************************

.SUBCKT NOR4BX2 AN B C D VDD VSS Y
*.PININFO AN:I B:I C:I D:I VDD:I VSS:I Y:O
Mmn4 Y D VSS VSS g45n1svt m=1 l=45n w=520n
Mmn1 Y n0 VSS VSS g45n1svt m=1 l=45n w=520n
Mmn3 Y C VSS VSS g45n1svt m=1 l=45n w=520n
Mmn0 n0 AN VSS VSS g45n1svt m=1 l=45n w=145n
Mmn2 Y B VSS VSS g45n1svt m=1 l=45n w=520n
Mmp4 Y D n3 VDD g45p1svt m=1 l=45n w=780n
Mmp0 n0 AN VDD VDD g45p1svt m=1 l=45n w=215n
Mmp3 n3 C n2 VDD g45p1svt m=1 l=45n w=780n
Mmp2 n2 B n1 VDD g45p1svt m=1 l=45n w=780n
Mmp1 n1 n0 VDD VDD g45p1svt m=1 l=45n w=780n
.ENDS
