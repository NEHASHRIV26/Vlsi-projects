************************************************************************
* auCdl Netlist:
*
* Library Name:  gsclib045
* Top Cell Name: AND4X8
* View Name:     schematic
* Netlisted on:  Jun  4 07:38:17 2012
************************************************************************

*.BIPOLAR
*.RESI = 2000
*.EQUATION
*.SCALE METER
*.MEGA
.PARAM

*.GLOBAL VSS:G
+        VDD:P
+        ExtVDD:P
+        ExtVSS:G

*.PIN VSS
*+    VDD
*+    ExtVDD
*+    ExtVSS

************************************************************************
* Library Name: gsclib045
* Cell Name:    AND4X8
* View Name:    schematic
************************************************************************

.SUBCKT AND4X8 A B C D VDD VSS Y
*.PININFO A:I B:I C:I D:I VDD:I VSS:I Y:O
Mmn3 net116 D net132 VSS g45n1svt m=1 l=45n w=520n
Mmn2 net132 C net128 VSS g45n1svt m=1 l=45n w=520n
Mmn4 Y net116 VSS VSS g45n1svt m=1 l=45n w=2.065u
Mmn1 net128 B net124 VSS g45n1svt m=1 l=45n w=520n
Mmn0 net124 A VSS VSS g45n1svt m=1 l=45n w=520n
Mmp3 net116 D VDD VDD g45p1svt m=1 l=45n w=780n
Mmp2 net116 C VDD VDD g45p1svt m=1 l=45n w=780n
Mmp1 net116 B VDD VDD g45p1svt m=1 l=45n w=780n
Mmp4 Y net116 VDD VDD g45p1svt m=1 l=45n w=3.115u
Mmp0 net116 A VDD VDD g45p1svt m=1 l=45n w=780n
.ENDS
