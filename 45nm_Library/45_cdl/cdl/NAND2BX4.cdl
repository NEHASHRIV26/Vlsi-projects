************************************************************************
* auCdl Netlist:
*
* Library Name:  gsclib045
* Top Cell Name: NAND2BX4
* View Name:     schematic
* Netlisted on:  Jun  4 07:45:03 2012
************************************************************************

*.BIPOLAR
*.RESI = 2000
*.EQUATION
*.SCALE METER
*.MEGA
.PARAM

*.GLOBAL VDD:P
+        VSS:G
+        ExtVDD:P
+        ExtVSS:G

*.PIN VDD
*+    VSS
*+    ExtVDD
*+    ExtVSS

************************************************************************
* Library Name: gsclib045
* Cell Name:    NAND2BX4
* View Name:    schematic
************************************************************************

.SUBCKT NAND2BX4 AN B VDD VSS Y
*.PININFO AN:I B:I VDD:I VSS:I Y:O
Mmn2 Y B n1 VSS g45n1svt m=1 l=45n w=1.04u
Mmn0 n0 AN VSS VSS g45n1svt m=1 l=45n w=260n
Mmn1 n1 n0 VSS VSS g45n1svt m=1 l=45n w=1.04u
Mmp1 Y n0 VDD VDD g45p1svt m=1 l=45n w=1.56u
Mmp2 Y B VDD VDD g45p1svt m=1 l=45n w=1.56u
Mmp0 n0 AN VDD VDD g45p1svt m=1 l=45n w=390n
.ENDS
