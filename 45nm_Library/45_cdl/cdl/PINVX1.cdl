************************************************************************
* auCdl Netlist:
*
* Library Name:  gsclib045
* Top Cell Name: PINVX1
* View Name:     schematic
* Netlisted on:  Jun  4 07:48:41 2012
************************************************************************

*.BIPOLAR
*.RESI = 2000
*.EQUATION
*.SCALE METER
*.MEGA
.PARAM

*.GLOBAL VSS:G
+        VDD:P
+        ExtVDD:P
+        ExtVSS:G

*.PIN VSS
*+    VDD
*+    ExtVDD
*+    ExtVSS

************************************************************************
* Library Name: gsclib045
* Cell Name:    PINVX1
* View Name:    schematic
************************************************************************

.SUBCKT PINVX1 A ExtVDD VDD VSS Y
*.PININFO A:I ExtVDD:I VDD:I VSS:I Y:O
Mmp0 Y A ExtVDD ExtVDD g45p1svt m=1 l=45n w=390n
Mmn0 Y A VSS VSS g45n1svt m=1 l=45n w=260n
.ENDS
