************************************************************************
* auCdl Netlist:
*
* Library Name:  gsclib045
* Top Cell Name: NAND2BX1
* View Name:     schematic
* Netlisted on:  Jun  4 07:45:00 2012
************************************************************************

*.BIPOLAR
*.RESI = 2000
*.EQUATION
*.SCALE METER
*.MEGA
.PARAM

*.GLOBAL VSS:G
+        VDD:P
+        ExtVDD:P
+        ExtVSS:G

*.PIN VSS
*+    VDD
*+    ExtVDD
*+    ExtVSS

************************************************************************
* Library Name: gsclib045
* Cell Name:    NAND2BX1
* View Name:    schematic
************************************************************************

.SUBCKT NAND2BX1 AN B VDD VSS Y
*.PININFO AN:I B:I VDD:I VSS:I Y:O
Mmn2 Y B n1 VSS g45n1svt m=1 l=45n w=260n
Mmn0 n0 AN VSS VSS g45n1svt m=1 l=45n w=145n
Mmn1 n1 n0 VSS VSS g45n1svt m=1 l=45n w=260n
Mmp1 Y n0 VDD VDD g45p1svt m=1 l=45n w=390n
Mmp2 Y B VDD VDD g45p1svt m=1 l=45n w=390n
Mmp0 n0 AN VDD VDD g45p1svt m=1 l=45n w=215n
.ENDS
