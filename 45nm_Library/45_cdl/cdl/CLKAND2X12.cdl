************************************************************************
* auCdl Netlist:
*
* Library Name:  gsclib045
* Top Cell Name: CLKAND2X12
* View Name:     schematic
* Netlisted on:  Jun  4 07:39:59 2012
************************************************************************

*.BIPOLAR
*.RESI = 2000
*.EQUATION
*.SCALE METER
*.MEGA
.PARAM

*.GLOBAL VSS:G
+        VDD:P
+        ExtVDD:P
+        ExtVSS:G

*.PIN VSS
*+    VDD
*+    ExtVDD
*+    ExtVSS

************************************************************************
* Library Name: gsclib045
* Cell Name:    CLKAND2X12
* View Name:    schematic
************************************************************************

.SUBCKT CLKAND2X12 A B VDD VSS Y
*.PININFO A:I B:I VDD:I VSS:I Y:O
Mmn2 Y net61 VSS VSS g45n1svt m=1 l=45n w=3.1u
Mmn0 net69 A VSS VSS g45n1svt m=1 l=45n w=1.55u
Mmn1 net61 B net69 VSS g45n1svt m=1 l=45n w=1.55u
Mmp1 net61 B VDD VDD g45p1svt m=1 l=45n w=1.175u
Mmp0 net61 A VDD VDD g45p1svt m=1 l=45n w=1.175u
Mmp2 Y net61 VDD VDD g45p1svt m=1 l=45n w=4.7u
.ENDS
