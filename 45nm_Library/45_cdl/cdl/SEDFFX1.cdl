************************************************************************
* auCdl Netlist:
*
* Library Name:  gsclib045
* Top Cell Name: SEDFFX1
* View Name:     schematic
* Netlisted on:  Jun  4 07:50:39 2012
************************************************************************

*.BIPOLAR
*.RESI = 2000
*.EQUATION
*.SCALE METER
*.MEGA
.PARAM

*.GLOBAL VSS:G
+        VDD:P
+        ExtVDD:P
+        ExtVSS:G

*.PIN VSS
*+    VDD
*+    ExtVDD
*+    ExtVSS

************************************************************************
* Library Name: gsclib045
* Cell Name:    SEDFFX1
* View Name:    schematic
************************************************************************

.SUBCKT SEDFFX1 CK D E Q QN SE SI VDD VSS
*.PININFO CK:I D:I E:I SE:I SI:I VDD:I VSS:I Q:O QN:O
Mmn4 Db E net554 VSS g45n1svt m=1 l=45n w=145n
Mmn3 net554 D VSS VSS g45n1svt m=1 l=45n w=145n
Mmn13 Dbp SE net546 VSS g45n1svt m=1 l=45n w=145n
Mmn12 net546 SI VSS VSS g45n1svt m=1 l=45n w=145n
Mmn57 QN net502 VSS VSS g45n1svt m=1 l=45n w=260n
Mmn55 Q net536 VSS VSS g45n1svt m=1 l=45n w=260n
Mmn50 net534 net536 VSS VSS g45n1svt m=1 l=45n w=145n
Mmn51 n30 CKb net534 VSS g45n1svt m=1 l=45n w=145n
Mmn35 net526 mout VSS VSS g45n1svt m=1 l=45n w=145n
Mmn36 n20 CKbb net526 VSS g45n1svt m=1 l=45n w=145n
Mmn20 CKb CK VSS VSS g45n1svt m=1 l=45n w=145n
Mmn1 net514 net502 VSS VSS g45n1svt m=1 l=45n w=145n
Mmn2 Db Eb net514 VSS g45n1svt m=1 l=45n w=145n
Mmn45 net536 n30 VSS VSS g45n1svt m=1 l=45n w=145n
Mmn56 net502 net536 VSS VSS g45n1svt m=1 l=45n w=145n
Mmn21 CKbb CKb VSS VSS g45n1svt m=1 l=45n w=145n
Mmn40 mout CKbb n30 VSS g45n1svt m=1 l=45n w=145n
Mmn10 SEb SE VSS VSS g45n1svt m=1 l=45n w=145n
Mmn30 mout n20 VSS VSS g45n1svt m=1 l=45n w=145n
Mmn0 Eb E VSS VSS g45n1svt m=1 l=45n w=145n
Mmn25 Dbp CKb n20 VSS g45n1svt m=1 l=45n w=145n
Mmn11 Db SEb Dbp VSS g45n1svt m=1 l=45n w=145n
Mmp4 Db Eb net473 VDD g45p1svt m=1 l=45n w=215n
Mmp3 net473 D VDD VDD g45p1svt m=1 l=45n w=215n
Mmp13 Dbp SEb net465 VDD g45p1svt m=1 l=45n w=215n
Mmp12 net465 SI VDD VDD g45p1svt m=1 l=45n w=215n
Mmp51 n30 CKbb net457 VDD g45p1svt m=1 l=45n w=215n
Mmp50 net457 net536 VDD VDD g45p1svt m=1 l=45n w=215n
Mmp57 QN net502 VDD VDD g45p1svt m=1 l=45n w=390n
Mmp55 Q net536 VDD VDD g45p1svt m=1 l=45n w=390n
Mmp35 net437 mout VDD VDD g45p1svt m=1 l=45n w=215n
Mmp36 n20 CKb net437 VDD g45p1svt m=1 l=45n w=215n
Mmp20 CKb CK VDD VDD g45p1svt m=1 l=45n w=215n
Mmp1 net425 net502 VDD VDD g45p1svt m=1 l=45n w=215n
Mmp2 Db E net425 VDD g45p1svt m=1 l=45n w=215n
Mmp45 net536 n30 VDD VDD g45p1svt m=1 l=45n w=215n
Mmp56 net502 net536 VDD VDD g45p1svt m=1 l=45n w=215n
Mmp21 CKbb CKb VDD VDD g45p1svt m=1 l=45n w=215n
Mmp40 n30 CKb mout VDD g45p1svt m=1 l=45n w=215n
Mmp30 mout n20 VDD VDD g45p1svt m=1 l=45n w=215n
Mmp0 Eb E VDD VDD g45p1svt m=1 l=45n w=215n
Mmp25 n20 CKbb Dbp VDD g45p1svt m=1 l=45n w=215n
Mmp11 Dbp SE Db VDD g45p1svt m=1 l=45n w=215n
Mmp10 SEb SE VDD VDD g45p1svt m=1 l=45n w=215n
.ENDS
