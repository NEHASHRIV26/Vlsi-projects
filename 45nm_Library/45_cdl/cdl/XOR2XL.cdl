************************************************************************
* auCdl Netlist:
*
* Library Name:  gsclib045
* Top Cell Name: XOR2XL
* View Name:     schematic
* Netlisted on:  Jun  4 07:52:42 2012
************************************************************************

*.BIPOLAR
*.RESI = 2000
*.EQUATION
*.SCALE METER
*.MEGA
.PARAM

*.GLOBAL VSS:G
+        VDD:P
+        ExtVDD:P
+        ExtVSS:G

*.PIN VSS
*+    VDD
*+    ExtVDD
*+    ExtVSS

************************************************************************
* Library Name: gsclib045
* Cell Name:    XOR2XL
* View Name:    schematic
************************************************************************

.SUBCKT XOR2XL A B VDD VSS Y
*.PININFO A:I B:I VDD:I VSS:I Y:O
Mmn1 n2 B VSS VSS g45n1svt m=1 l=45n w=145n
Mmn0 n1 A VSS VSS g45n1svt m=1 l=45n w=145n
Mmn5 Y n0 VSS VSS g45n1svt m=1 l=45n w=145n
Mmn3 n0 B net131 VSS g45n1svt m=1 l=45n w=145n
Mmn4 n0 n2 n1 VSS g45n1svt m=1 l=45n w=145n
Mmn2 net131 n1 VSS VSS g45n1svt m=1 l=45n w=145n
Mmp3 n0 n2 net130 VDD g45p1svt m=1 l=45n w=215n
Mmp1 n2 B VDD VDD g45p1svt m=1 l=45n w=215n
Mmp4 n1 B n0 VDD g45p1svt m=1 l=45n w=215n
Mmp0 n1 A VDD VDD g45p1svt m=1 l=45n w=215n
Mmp5 Y n0 VDD VDD g45p1svt m=1 l=45n w=215n
Mmp2 net130 n1 VDD VDD g45p1svt m=1 l=45n w=215n
.ENDS
