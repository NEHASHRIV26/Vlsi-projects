************************************************************************
* auCdl Netlist:
*
* Library Name:  gsclib045
* Top Cell Name: AOI31X2
* View Name:     schematic
* Netlisted on:  Jun  4 07:39:24 2012
************************************************************************

*.BIPOLAR
*.RESI = 2000
*.EQUATION
*.SCALE METER
*.MEGA
.PARAM

*.GLOBAL VDD:P
+        VSS:G
+        ExtVDD:P
+        ExtVSS:G

*.PIN VDD
*+    VSS
*+    ExtVDD
*+    ExtVSS

************************************************************************
* Library Name: gsclib045
* Cell Name:    AOI31X2
* View Name:    schematic
************************************************************************

.SUBCKT AOI31X2 A0 A1 A2 B0 VDD VSS Y
*.PININFO A0:I A1:I A2:I B0:I VDD:I VSS:I Y:O
Mmn3 Y B0 VSS VSS g45n1svt m=1 l=45n w=520n
Mmn1 net100 A1 net104 VSS g45n1svt m=1 l=45n w=520n
Mmn2 Y A2 net100 VSS g45n1svt m=1 l=45n w=520n
Mmn0 net104 A0 VSS VSS g45n1svt m=1 l=45n w=520n
Mmp2 net81 A2 VDD VDD g45p1svt m=1 l=45n w=780n
Mmp3 Y B0 net81 VDD g45p1svt m=1 l=45n w=780n
Mmp1 net81 A1 VDD VDD g45p1svt m=1 l=45n w=780n
Mmp0 net81 A0 VDD VDD g45p1svt m=1 l=45n w=780n
.ENDS
