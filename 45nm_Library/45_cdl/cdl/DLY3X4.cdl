************************************************************************
* auCdl Netlist:
*
* Library Name:  gsclib045
* Top Cell Name: DLY3X4
* View Name:     schematic
* Netlisted on:  Jun  4 07:42:14 2012
************************************************************************

*.BIPOLAR
*.RESI = 2000
*.EQUATION
*.SCALE METER
*.MEGA
.PARAM

*.GLOBAL VSS:G
+        VDD:P
+        ExtVDD:P
+        ExtVSS:G

*.PIN VSS
*+    VDD
*+    ExtVDD
*+    ExtVSS

************************************************************************
* Library Name: gsclib045
* Cell Name:    DLY3X4
* View Name:    schematic
************************************************************************

.SUBCKT DLY3X4 A VDD VSS Y
*.PININFO A:I VDD:I VSS:I Y:O
Mmn10 n5 VDD n15 VSS g45n1svt m=1 l=45n w=145n
Mmn9 n15 n4 VSS VSS g45n1svt m=1 l=45n w=145n
Mmn8 n4 VDD n13 VSS g45n1svt m=1 l=45n w=145n
Mmn7 n13 n3 VSS VSS g45n1svt m=1 l=45n w=145n
Mmn6 n3 VDD n11 VSS g45n1svt m=1 l=45n w=145n
Mmn5 n11 n2 VSS VSS g45n1svt m=1 l=45n w=145n
Mmn4 n2 VDD n9 VSS g45n1svt m=1 l=45n w=145n
Mmn3 n9 n1 VSS VSS g45n1svt m=1 l=45n w=145n
Mmn2 n1 VDD n7 VSS g45n1svt m=1 l=45n w=145n
Mmn1 n7 n0 VSS VSS g45n1svt m=1 l=45n w=145n
Mmn11 n6 n5 VSS VSS g45n1svt m=1 l=45n w=260n
Mmn12 Y n6 VSS VSS g45n1svt m=1 l=45n w=1.04u
Mmn0 n0 A VSS VSS g45n1svt m=1 l=45n w=145n
Mmp8 n4 VSS n14 VDD g45p1svt m=1 l=45n w=215n
Mmp7 n14 n3 VDD VDD g45p1svt m=1 l=45n w=215n
Mmp9 n16 n4 VDD VDD g45p1svt m=1 l=45n w=215n
Mmp10 n5 VSS n16 VDD g45p1svt m=1 l=45n w=215n
Mmp6 n3 VSS n12 VDD g45p1svt m=1 l=45n w=215n
Mmp5 n12 n2 VDD VDD g45p1svt m=1 l=45n w=215n
Mmp4 n2 VSS n10 VDD g45p1svt m=1 l=45n w=215n
Mmp3 n10 n1 VDD VDD g45p1svt m=1 l=45n w=215n
Mmp2 n1 VSS n8 VDD g45p1svt m=1 l=45n w=215n
Mmp1 n8 n0 VDD VDD g45p1svt m=1 l=45n w=215n
Mmp12 Y n6 VDD VDD g45p1svt m=1 l=45n w=1.56u
Mmp0 n0 A VDD VDD g45p1svt m=1 l=45n w=215n
Mmp11 n6 n5 VDD VDD g45p1svt m=1 l=45n w=390n
.ENDS
