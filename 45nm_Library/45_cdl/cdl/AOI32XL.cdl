************************************************************************
* auCdl Netlist:
*
* Library Name:  gsclib045
* Top Cell Name: AOI32XL
* View Name:     schematic
* Netlisted on:  Jun  4 07:39:35 2012
************************************************************************

*.BIPOLAR
*.RESI = 2000
*.EQUATION
*.SCALE METER
*.MEGA
.PARAM

*.GLOBAL VDD:P
+        VSS:G
+        ExtVDD:P
+        ExtVSS:G

*.PIN VDD
*+    VSS
*+    ExtVDD
*+    ExtVSS

************************************************************************
* Library Name: gsclib045
* Cell Name:    AOI32XL
* View Name:    schematic
************************************************************************

.SUBCKT AOI32XL A0 A1 A2 B0 B1 VDD VSS Y
*.PININFO A0:I A1:I A2:I B0:I B1:I VDD:I VSS:I Y:O
Mmn3 net118 B0 VSS VSS g45n1svt m=1 l=45n w=145n
Mmn2 Y A2 net130 VSS g45n1svt m=1 l=45n w=145n
Mmn0 net126 A0 VSS VSS g45n1svt m=1 l=45n w=145n
Mmn1 net130 A1 net126 VSS g45n1svt m=1 l=45n w=145n
Mmn4 Y B1 net118 VSS g45n1svt m=1 l=45n w=145n
Mmp3 Y B0 net114 VDD g45p1svt m=1 l=45n w=215n
Mmp4 Y B1 net114 VDD g45p1svt m=1 l=45n w=215n
Mmp2 net114 A2 VDD VDD g45p1svt m=1 l=45n w=215n
Mmp1 net114 A1 VDD VDD g45p1svt m=1 l=45n w=215n
Mmp0 net114 A0 VDD VDD g45p1svt m=1 l=45n w=215n
.ENDS
